|   PPC440EP IBIS Model
|   AMCC Confidential
[IBIS Ver]   3.2
[File Name]   ppc440ep_rev16.ibs
[File Rev]   1.6
[Date]   April 26, 2007
[Source]   AMCC Applications Group
[Notes]   Please direct all inquiries regarding this model
   to Embedded PowerPC Technical Support: support@amcc.com
   Version   Date
   1.00   14-OCT-03  PPC440EP  Model (35mm E-PBGA package)
   1.01   02-FEB-04  IO Swap and new RLC values
   1.02   16-APR-04  Correct part number & disclaimer
   1.3   01-OCT-04  New bpcix3 models : selector names changed
   and Vinl/Vinh values modified
   1.4   04-OCT-04  Diff Pin section added
   1.5   29-MAR-05  Vinl/Vinh modified on sstl I/Os
   1.6   26-APR-07  Edit by Pete Duong to change Cref from 10pF
   to 50pF for EBC buffers, 50pF is specified
   on datasheet as Cload.
This file applies to all speed sorts, 333, 400, 466 and 533MHz.  The speed in
the Component field below may be modified for the core frequency in use.  The
I/O timings will not change with CPU speed.
[Disclaimer] This information is for modeling purposes only, and is not
                guaranteed.
                THIS INFORMATION IS PROVIDED "AS IS" WITHOUT WARRANTY OF ANY
                KIND, EITHER EXPRESS OR IMPLIED, INCLUDING WITHOUT LIMITATION,
                THE IMPLIED WARRANTIES OF MERCHANTABILITY, FITNESS FOR A
                PARTICULAR PURPOSE, AND NON-INFRINGEMENT.  SOME JURISDICTIONS
                DO NOT ALLOW THE EXCLUSION OF IMPLIED WARRANTIES, SO THE
                ABOVE EXCLUSION MAY NOT APPLY TO YOU.
                This Information may contain technical inaccuracies or
                typographical errors.  AMCC reserves the right to modify or
                withdraw this information at any time without notice.
                All information contained in this document was obtained in
                specific environments, and is presented as an illustration.
                The results obtained in other operating environments may vary.
                IN NO EVENT WILL AMCC BE LIABLE TO ANY PARTY FOR ANY DIRECT,
                INDIRECT, SPECIAL OR CONSEQUENTIAL DAMAGES FOR ANY USE OF
                THIS INFORMATION, INCLUDING, WITHOUT LIMITATION, ANY LOST
                PROFITS, BUSINESS INTERRUPTION, LOSS OF PROGRAMS OR OTHER
                DATA ON YOUR INFORMATION HANDLING SYSTEM OR OTHERWISE, EVEN
                IF WE ARE EXPRESSLY ADVISED OF THE POSSIBILITY OF SUCH
                DAMAGES.
                The information contained in this document is subject to
                change without notice.  The information contained in this
                document does not affect or change AMCC's product specification
                or warranties.  Nothing in this document shall operate as an
                express or implied license or indemnity under the intellectual
                property rights of AMCC or third parties.
[Copyright]   Copyright 2005, AMCC. All Rights Reserved
[Component]   PPC440EP-3JB400C
[Manufacturer]  IBM
[Package]
|   typ   min  max
R_pkg   0.5   0.3   0.8
L_pkg   11.1n 7.3n  18.4n
C_pkg   2.0p  1.3p   2.9p
[Pin]  signal_name   model_name   R_pin   L_pin  C_pin
 A01  GND   gnd
 A02  GND   gnd
 A03  TestEn   it33tepdt_pm_a   0.5   18.4n   1.3p
 A04  PerCS2_N   bt3350t_pm_a   0.6   14.5n   2.3p
 A05  PerAddr05   bt3335_pm_b   0.8   16.5n   2.1p
 A06  GND   gnd
 A07  PerAddr09   bt3335_pm_b   0.5   12.3n   2.3p
 A08  PerAddr13   bt3335_pm_b   0.5   12.3n   1.9p
 A09  GND   gnd
 A10  PerCS5_N   bt3350_pm_a   0.5   10.9n   1.9p
 A11  GND   gnd
 A12  PerAddr23   bt3335_pm_b   0.5   11.4n   2.0p
 A13  PerAddr22   bt3335_pm_b   0.5   12.4n   2.0p
 A14  PerAddr24   bt3335_pm_b   0.5   12.3n   1.9p
 A15  PerAddr28   bt3335_pm_b   0.5   11.3n   1.7p
 A16  GND   gnd
 A17  PCIAD03   bpcix3_a   0.5   10.9n   2.0p
 A18  PCIAD05   bpcix3_a   0.6   12.5n   1.9p
 A19  IRQ9   bt3350_pm_a   0.5   11.3n   2.2p
 A20  PCIAD09   bpcix3_a   0.6   12.6n   2.0p
 A21  GND   gnd
 A22  PCIReq4_N   bpcix3_a   0.6   13.5n   2.1p
 A23  PCIAD12   bpcix3_a   0.6   13.1n   2.1p
 A24  PCIAD13   bpcix3_a   0.6   14.0n   2.1p
 A25  PCIGnt2_N   bpcix3_a   0.6   15.3n   2.3p
 A26  GND   gnd
 B01  PerData15   bt3335_pm_b   0.5   13.3n   1.9p
 B02  GND   gnd
 B03  PerOE_N   bt3335t_pm_b   0.5   14.1n   2.4p
 B04  PerAddr02   bt3335_pm_b   0.5   15.8n   1.7p
 B05  TCK   bt3350pu_pm_a   0.6   13.1n   2.3p
 B06  PerAddr06   bt3335t_pm_b   0.6   14.0n   2.4p
 B07  PerCS3_N   bt3350_pm_a   0.5   11.7n   1.9p
 B08  PerAddr11   bt3335t_pm_b   0.5   11.4n   2.1p
 B09  PerAddr14   bt3335_pm_b   0.5   11.0n   2.0p
 B10  PerCS4_N   bt3350_pm_a   0.5   9.9n   2.0p
 B11  PerAddr19   bt3335_pm_b   0.5   10.4n   1.8p
 B12  PerAddr20   bt3335t_pm_b   0.4   9.7n   1.8p
 B13  PerAddr25   bt3335_pm_b   0.5   10.4n   1.9p
 B14  PerAddr27   bt3335_pm_b   0.4   10.2n   1.6p
 B15  PerAddr29   bt3335_pm_b   0.5   10.6n   1.7p
 B16  PCIAD00   bpcix3_a   0.5   10.3n   1.7p
 B17  PCIAD04   bpcix3_a   0.5   10.2n   1.9p
 B18  PCIC0/BE0_N   bpcix3_a   0.5   11.6n   1.9p
 B19  PCIReq2_N   bpcix3t_a   0.5   12.0n   2.0p
 B20  PCIReq1_N   bpcix3t_a   0.5   11.6n   2.2p
 B21  PCIClk   bpcix3_a   0.4   10.7n   2.6p
 B22  PCIAD11   bpcix3_a   0.6   13.5n   2.2p
 B23  ExtReset_N   bt3335_pm_a   0.5   12.7n   2.0p
 B24  IRQ7   bt3350_pm_a   0.4   8.0n   1.9p
 B25  GND   gnd
 B26  GND   gnd
 C01  PerData12   bt3335_pm_b   0.6   13.8n   2.2p
 C02  PerClk   bt3335_pm_b   0.5   11.2n   2.9p
 C03  GND   gnd
 C04  PerWBE1_N   bt3335_pm_b   0.5   12.8n   2.1p
 C05  PerReady   bt3335_pm_a   0.5   13.2n   1.6p
 C06  PerCS1_N   bt3350_pm_a   0.5   11.8n   2.0p
 C07  PerAddr03   bt3335_pm_b   0.6   12.4n   2.4p
 C08  PerAddr07   bt3335_pm_b   0.5   11.0n   2.2p
 C09  PerAddr10   bt3335_pm_b   0.5   10.6n   2.0p
 C10  PerAddr15   bt3335t_pm_b   0.4   9.2n   2.0p
 C11  PerAddr16   bt3335_pm_b   0.4   9.2n   1.8p
 C12  PerAddr18   bt3335_pm_b   0.4   8.7n   1.8p
 C13  PerAddr26   bt3335_pm_b   0.4   9.2n   1.8p
 C14  PerAddr30   bt3335_pm_b   0.4   9.2n   1.6p
 C15  PCIAD01   bpcix3_a   0.4   8.8n   1.8p
 C16  PCIAD06   bpcix3_a   0.4   9.2n   1.8p
 C17  TDI   bt3350pu_pm_a   0.5   10.0n   1.9p
 C18  PCIAD08   bpcix3_a   0.5   10.2n   2.3p
 C19  PCIReq3_N   bpcix3_a   0.5   10.6n   2.6p
 C20  PCIAD10   bpcix3_a   0.5   11.8n   2.3p
 C21  TDO   bt3350_pm_a   0.5   10.7n   2.3p
 C22  PCIAD14   bpcix3_a   0.5   11.4n   2.2p
 C23  PCIPar   bpcix3_a   0.5   11.7n   2.6p
 C24  GND   gnd
 C25  Halt_N   it33d2put_pm_a   0.6   15.7n   2.4p
 C26  PSROOut   nc   0.6   13.9n   2.5p
 D01  PerData10   bt3335_pm_b   0.6   13.3n   2.3p
 D02  TMS   bt3350pu_pm_a   0.6   12.6n   2.3p
 D03  IRQ0   bt3350_pm_a   0.5   13.0n   2.2p
 D04  GND   gnd
 D05  PerR/W_N   bt3335_pm_b   0.5   12.0n   1.8p
 D06  PerCS0_N   bt3350_pm_a   0.4   12.0n   1.7p
 D07  TRST_N   bt3350pu_pm_a   0.5   10.8n   2.1p
 D08  PerAddr04   bt3335_pm_b   0.4   9.7n   2.1p
 D09  PerAddr08   bt3335_pm_b   0.4   9.2n   1.9p
 D10  PerAddr12   bt3335_pm_b   0.4   8.9n   1.9p
 D11  PerBLast_N   bt3335_pm_b   0.4   8.4n   1.7p
 D12  PerAddr17   bt3335_pm_b   0.4   7.9n   1.8p
 D13  PerAddr21   bt3335_pm_b   0.4   7.9n   1.7p
 D14  PerAddr31   bt3335_pm_b   0.4   8.1n   1.7p
 D15  PCIAD02   bpcix3t_a   0.4   7.4n   1.9p
 D16  PCIAD07   bpcix3t_a   0.4   7.5n   2.3p
 D17  PCIGnt0_N/Req   bpcix3_a   0.4   9.2n   1.9p
 D18  IRQ8   bt3350_pm_a   0.5   15.1n   1.6p
 D19  PCIReset_N   bpcix3t_a   0.4   9.7n   1.8p
 D20  PCIINT_N   bpcix3t_a   0.4   10.0n   2.1p
 D21  GND   gnd
 D22  PCIAD15   bpcix3t_a   0.5   10.5n   2.5p
 D23  GND   gnd
 D24  PCIPErr_N   bpcix3_a   0.5   12.2n   2.2p
 D25  PCIGnt3_N   bpcix3_a   0.6   13.2n   2.4p
 D26  PCIDevSel_N   bpcix3t_a   0.6   13.6n   2.4p
 E01  PerData06   bt3335_pm_b   0.6   13.9n   2.3p
 E02  PerData09   bt3335_pm_b   0.5   12.6n   2.1p
 E03  PerData14   bt3335_pm_b   0.5   11.0n   2.0p
 E04  PerErr   bt3350t_pm_a   0.4   9.7n   2.4p
 E05  VDD   power
 E06  OVDD   power
 E07  OVDD   power
 E08  OVDD   power
 E09  GND   gnd
 E10  VDD   power
 E11  VDD   power
 E12  VDD   power
 E13  OVDD   power
 E14  GND   gnd
 E15  VDD   power
 E16  VDD   power
 E17  VDD   power
 E18  GND   gnd
 E19  OVDD   power
 E20  OVDD   power
 E21  OVDD   power
 E22  VDD   power
 E23  PCIStop_N   bpcix3_a   0.6   15.6n   2.3p
 E24  PCIGnt5_N   bpcix3_a   0.6   14.3n   2.3p
 E25  PCIIRDY_N   bpcix3t_a   0.5   12.3n   2.4p
 E26  PCIC3/BE3_N   bpcix3_a   0.6   14.8n   2.1p
 F01  GND   gnd
 F02  IRQ2   bt3350_pm_a   0.4   9.1n   1.8p
 F03  PerData11   bt3335t_pm_b   0.5   10.5n   2.3p
 F04  PerData13   bt3335t_pm_b   0.4   9.6n   2.2p
 F05  OVDD   power
 F22  OVDD   power
 F23  PCIC1/BE1_N   bpcix3_a   0.5   11.4n   2.1p
 F24  PCIC2/BE2_N   bpcix3_a   0.5   11.6n   2.2p
 F25  PCIAD17   bpcix3t_a   0.6   14.3n   2.3p
 F26  GND   gnd
 G01  PerData02   bt3335_pm_b   0.5   12.7n   2.0p
 G02  IRQ3   bt3350t_pm_a   0.4   7.7n   1.8p
 G03  PerData07   bt3335_pm_b   0.5   11.1n   2.4p
 G04  IRQ1   bt3350t_pm_a   0.5   10.2n   2.2p
 G05  OVDD   power
 G22  OVDD   power
 G23  PCITRDY_N   bpcix3_a   0.4   10.0n   2.2p
 G24  PCIFrame_N   bpcix3_a   0.5   10.3n   2.3p
 G25  IRQ4   bt3350_pm_a   0.4   8.8n   1.8p
 G26  PCIIDSel   bpcix3t_a   0.5   13.9n   2.0p
 H01  PerData00   bt3335t_pm_b   0.6   12.6n   1.9p
 H02  PerWBE0_N   bt3335_pm_b   0.5   11.7n   2.0p
 H03  PerData05   bt3335_pm_b   0.5   11.1n   2.0p
 H04  PerData08   bt3335_pm_b   0.4   10.4n   2.3p
 H05  OVDD   power
 H22  OVDD   power
 H23  IRQ6   bt3350_pm_a   0.5   11.6n   2.2p
 H24  PCIAD16   bpcix3_a   0.6   13.3n   2.3p
 H25  PCIGnt4_N   bpcix3t_a   0.5   12.4n   2.1p
 H26  PCIReq5_N   bpcix3_a   0.5   12.5n   1.9p
 J01  DM2   bsstl2c2_a   0.5   11.5n   1.8p
 J02  CAS_N   bsstl2c2_a   0.5   11.0n   1.8p
 J03  PerData03   bt3335_pm_b   0.4   9.9n   2.1p
 J04  PerData04   bt3335_pm_b   0.4   9.2n   1.9p
 J05  GND   gnd
 J22  GND   gnd
 J23  PCISErr_N   bpcix3_a   0.4   10.9n   1.9p
 J24  PCIAD18   bpcix3_a   0.5   10.5n   2.0p
 J25  PCIAD21   bpcix3_a   0.5   12.0n   1.9p
 J26  GND   gnd
 K01  WE_N   bsstl2c2_a   0.5   10.8n   1.9p
 K02  RAS_N   bsstl2c2_a   0.5   10.3n   1.9p
 K03  DQS2   bsstl2c2_a   0.4   9.6n   1.9p
 K04  PerData01   bt3335_pm_b   0.4   9.2n   1.9p
 K05  VDD   power
 K22  VDD   power
 K23  PCIAD19   bpcix3_a   0.4   9.2n   1.9p
 K24  PCIAD20   bpcix3t_a   0.4   9.9n   2.0p
 K25  PCIAD23   bpcix3t_a   0.5   10.1n   1.9p
 K26  PCIAD24   bpcix3_a   0.5   10.6n   1.9p
 L01  GND   gnd
 L02  ECC6   bsstl2c2_a   0.5   10.2n   1.8p
 L03  DM3   bsstl2c2_a   0.4   9.0n   1.9p
 L04  GND   gnd
 L05  VDD   power
 L11  GND   gnd
 L12  OVDD   power
 L13  GND   gnd
 L14  GND   gnd
 L15  OVDD   power
 L16  GND   gnd
 L22  VDD   power
 L23  PCIAD22   bpcix3_a   0.4   8.7n   1.8p
 L24  PCIGnt1_N   bpcix3_a   0.4   9.4n   1.8p
 L25  PCIAD27   bpcix3_a   0.5   10.2n   1.7p
 L26  GND   gnd
 M01  ECC2   bsstl2c2_a   0.5   11.1n   1.7p
 M02  ECC3   bsstl2c2_a   0.5   10.3n   1.7p
 M03  ECC7   bsstl2c2_a   0.4   8.7n   1.8p
 M04  DQS3   bsstl2c2_a   0.4   7.4n   1.9p
 M05  VDD   power
 M11  OVDD   power
 M12  GND   gnd
 M13  GND   gnd
 M14  VDD   power
 M15  GND   gnd
 M16  OVDD   power
 M22  VDD   power
 M23  PCIAD26   bpcix3_a   0.4   7.3n   1.8p
 M24  PCIAD25   bpcix3_a   0.4   8.2n   1.8p
 M25  GND   gnd
 M26  PCIAD30   bpcix3_a   0.5   11.7n   1.9p
 N01  BankSel3_N   bsstl2c2_a   0.5   12.3n   1.9p
 N02  ECC1   bsstl2c2t_a   0.4   9.7n   1.8p
 N03  ECC4   bsstl2c2_a   0.4   8.8n   1.7p
 N04  ECC5   bsstl2c2_a   0.4   7.6n   1.7p
 N05  GND   gnd
 N11  GND   gnd
 N12  VDD   power
 N13  GND   gnd
 N14  GND   gnd
 N15  GND   gnd
 N16  GND   gnd
 N22  OVDD   power
 N23  PCIAD28   bpcix3_a   0.4   8.1n   1.7p
 N24  UART0_DTR_N   bt3350_pm_a   0.4   9.5n   1.7p
 N25  PCIReq0_N/Gnt   bpcix3_a   0.5   10.4n   1.8p
 N26  PCIAD29   bpcix3_a   0.5   12.5n   1.9p
 P01  MemAddr00   bsstl2c2_a   0.5   12.0n   1.9p
 P02  ECC0   bsstl2c2_a   0.4   10.1n   2.0p
 P03  SVREF2A   power
 P04  MemAddr01   bsstl2c2_a   0.4   7.5n   1.7p
 P05  SVDD   power
 P11  GND   gnd
 P12  GND   gnd
 P13  GND   gnd
 P14  GND   gnd
 P15  VDD   power
 P16  GND   gnd
 P22  GND   gnd
 P23  UARTSerClk   bt3350_pm_a   0.4   7.7n   1.6p
 P24  UART0_RI_N   bt3350_pm_a   0.4   9.1n   1.6p
 P25  UART0_Tx   bt3350_pm_a   0.4   10.4n   1.6p
 P26  PCIAD31   bpcix3_a   0.5   12.4n   1.9p
 R01  BankSel2_N   bsstl2c2_a   0.5   11.1n   2.0p
 R02  BankSel1_N   bsstl2c2t_a   0.4   8.7n   2.0p
 R03  MemAddr10   bsstl2c2_a   0.4   8.2n   1.8p
 R04  BankSel0_N   bsstl2c2_a   0.4   7.5n   1.7p
 R05  VDD   power
 R11  SVDD   power
 R12  GND   gnd
 R13  VDD   power
 R14  GND   gnd
 R15  GND   gnd
 R16  SVDD   power
 R22  VDD   power
 R23  USB1DevXcvr   busb5_pm_a   0.4   9.0n   1.9p
 R24  USB1DevXcvr_N   busb5_pm_a   0.4   9.0n   1.8p
 R25  UART0_DCD_N   bt3350_pm_a   0.5   10.8n   1.7p
 R26  UART0_RTS_N   bt3350_pm_a   0.5   11.4n   1.7p
 T01  GND   gnd
 T02  MemAddr02   bsstl2c2_a   0.5   9.6n   1.8p
 T03  MemData30   bsstl2c2_a   0.4   9.1n   1.8p
 T04  MemAddr03   bsstl2c2_a   0.4   8.6n   1.7p
 T05  VDD   power
 T11  GND   gnd
 T12  SVDD   power
 T13  GND   gnd
 T14  GND   gnd
 T15  SVDD   power
 T16  GND   gnd
 T22  VDD   power
 T23  SCPDO   bt3335t_pm_a   0.4   8.5n   2.0p
 T24  IIC0SData   bt3335_pm_a   0.4   9.2n   1.8p
 T25  UART0_Rx   bt3350_pm_a   0.4   9.9n   1.7p
 T26  GND   gnd
 U01  MemAddr04   bsstl2c2_a   0.5   10.9n   1.8p
 U02  MemData31   bsstl2c2t_a   0.5   10.0n   2.0p
 U03  MemData29   bsstl2c2_a   0.5   9.8n   2.0p
 U04  MemAddr06   bsstl2c2_a   0.5   10.6n   1.9p
 U05  VDD   power
 U22  VDD   power
 U23  USB2DO7   bp2550_a   0.6   12.8n   1.9p
 U24  SCPClkOut   bt3335_pm_a   0.4   9.9n   1.7p
 U25  IIC0SClk   bt3335_pm_a   0.4   10.8n   1.8p
 U26  UART0_DSR_N   bt3350_pm_a   0.5   11.6n   1.7p
 V01  GND   gnd
 V02  MemAddr05   bsstl2c2_a   0.5   11.1n   1.9p
 V03  MemData26   bsstl2c2_a   0.4   10.0n   2.0p
 V04  MemData24   bsstl2c2_a   0.4   9.3n   1.9p
 V05  GND   gnd
 V22  GND   gnd
 V23  USB2DO5   bp2550_a   0.4   9.4n   2.1p
 V24  USB2LS1   ip25ltt_a   0.4   10.6n   1.9p
 V25  SCPDI   bt3335_pm_a   0.5   11.2n   1.8p
 V26  UART0_CTS_N   bt3350_pm_a   0.5   12.0n   1.9p
 W01  MemData28   bsstl2c2_a   0.6   12.5n   1.9p
 W02  MemData27   bsstl2c2t_a   0.5   12.1n   2.0p
 W03  MemAddr07   bsstl2c2_a   0.5   11.0n   2.1p
 W04  SVREF1   power
 W05  SVDD   power
 W22  SVDD   power
 W23  USB2TxRdy   ip25ret_a   0.4   10.3n   2.1p
 W24  USB2OM0   bp2535_a   0.5   11.8n   2.0p
 W25  USB1HostXcvr   busb5_pm_a   0.5   12.4n   2.0p
 W26  USB1HostXcvr_N  busb5_pm_a   0.6   13.1n   1.9p
 Y01  MemData25   bsstl2c2t_a   0.5   12.8n   2.0p
 Y02  MemAddr08   bsstl2c2_a   0.5   11.8n   2.0p
 Y03  TrcES0   bp2550_a   0.5   10.3n   2.2p
 Y04  MemData22   bsstl2c2_a   0.5   9.9n   2.0p
 Y05  SVDD   power
 Y22  SVDD   power
 Y23  USB2RxAct   ip25rit_a   0.5   10.6n   2.4p
 Y24  USB2TxVal   bp2535_b   0.6   13.1n   2.3p
 Y25  USB2LS0   ip25d1t_a   0.6   13.0n   2.1p
 Y26  USB2DO6   bp2550_a   0.6   13.4n   2.2p
AA01  GND   gnd
AA02  MemData23   bsstl2c2t_a   0.6   14.0n   2.3p
AA03  MemData21   bsstl2c2_a   0.5   11.7n   2.2p
AA04  TrcES1   bp2550_a   0.5   10.1n   2.3p
AA05  SVDD   power
AA22  SVDD   power
AA23  USB2TermSel   bp2535t_b   0.4   11.1n   2.0p
AA24  TrcBS2   bp2550_a   0.4   10.0n   2.2p
AA25  USB2XcvrSel   bp2535_b   0.7   15.8n   2.0p
AA26  GND   gnd
AB01  SysErr   bp2550_a   0.6   14.0n   2.1p
AB02  MemAddr09   bsstl2c2t_a   0.5   12.1n   2.1p
AB03  TrcES2   bp2550_a   0.5   11.0n   2.2p
AB04  TrcES3   bp2550_a   0.5   10.2n   2.3p
AB05  VDD   power
AB06  SVDD   power
AB07  SVDD   power
AB08  SVDD   power
AB09  GND   gnd
AB10  VDD   power
AB11  VDD   power
AB12  VDD   power
AB13  GND   gnd
AB14  SVDD   power
AB15  VDD   power
AB16  VDD   power
AB17  VDD   power
AB18  GND   gnd
AB19  SVDD   power
AB20  SVDD   power
AB21  SVDD   power
AB22  VDD   power
AB23  USB2DI5   bp2550t_a   0.5   9.6n   2.4p
AB24  USB2DI7   bp2550_a   0.5   11.6n   1.9p
AB25  USB2Susp   bp2535_b   0.6   13.8n   2.2p
AB26  USB2OM1   bp2535_a   0.6   14.1n   2.3p
AC01  GND   gnd
AC02  MemData20   bsstl2c2_a   0.6   13.2n   2.3p
AC03  MemData19   bsstl2c2_a   0.5   11.4n   2.2p
AC04  GND   gnd
AC05  MemData17   bsstl2c2t_a   0.4   11.1n   2.6p
AC06  DQS8   bsstl2c2_a   0.4   12.1n   2.0p
AC07  GND   gnd
AC08  DQS1   bsstl2c2_a   0.5   11.4n   2.0p
AC09  TrcTS4   bp2550_a   0.6   13.0n   2.6p
AC10  MemData12   bsstl2c2_a   0.4   8.6n   2.0p
AC11  MemData06   bsstl2c2t_a   0.4   7.9n   1.8p
AC12  IRQ5   ip25mct_a   0.4   9.2n   1.7p
AC13  MemData02   bsstl2c2_a   0.4   7.7n   1.7p
AC14  EMCTxD3   bp2550_a   0.4   7.4n   1.8p
AC15  EMCTxClk   bp2550_a   0.3   7.6n   1.8p
AC16  EMCCD   bp2550_a   0.4   8.9n   1.8p
AC17  EMCRxD3   bp2550_a   0.4   7.7n   1.9p
AC18  EMCMDIO   bp2550_a   0.4   8.4n   2.1p
AC19  TrcClk   bp2550_a   0.4   10.1n   2.9p
AC20  USB2DO2   bp2550_a   0.4   9.4n   2.2p
AC21  USB2DI3   bp2550_a   0.5   9.9n   2.0p
AC22  TrcTS0   bp2550_a   0.4   10.4n   2.2p
AC23  GND   gnd
AC24  USB2DI6   bp2550_a   0.5   10.9n   2.3p
AC25  TrcBS1   bp2550_a   0.5   13.0n   2.2p
AC26  USB2RxDV   bp2535_b   0.6   14.4n   2.3p
AD01  MemAddr11   bsstl2c2t_a   0.6   13.4n   2.5p
AD02  MemAddr12   bsstl2c2t_a   0.5   12.7n   2.4p
AD03  GND   gnd
AD04  TrcTS2   bp2550_a   0.5   12.8n   2.0p
AD05  MemData15   bsstl2c2_a   0.5   13.0n   1.7p
AD06  TrcTS3   bp2550t_a   0.4   9.2n   2.1p
AD07  DM1   bsstl2c2_a   0.5   10.2n   2.3p
AD08  MemData14   bsstl2c2_a   0.4   10.0n   1.9p
AD09  DQS0   bsstl2c2_a   0.4   9.9n   2.1p
AD10  MemData09   bsstl2c2_a   0.4   9.5n   2.0p
AD11  TmrClk   bp2550_a   0.4   9.5n   1.7p
AD12  TrcTS5   bp2550_a   0.4   9.3n   2.7p
AD13  MemData01   bsstl2c2_a   0.4   8.6n   1.8p
AD14  EMCTxD0   bp2550_a   0.4   9.2n   1.7p
AD15  EMCCrS   bp2550_a   0.4   8.8n   1.8p
AD16  EMCRxErr   bp2550_a   0.5   10.3n   1.8p
AD17  AVDD   power
AD18  EMCRxD2   bp2550_a   0.4   9.4n   2.0p
AD19  EMCRxD0   bp2550t_a   0.4   9.4n   2.1p
AD20  USB2DO0   bp2550_a   0.5   10.3n   2.3p
AD21  USB2DI0   bp2550_a   0.5   11.0n   2.1p
AD22  USB2Clk   bp2550_a   0.4   9.8n   2.4p
AD23  USB2DO4   bp2550_a   0.5   11.9n   2.2p
AD24  GND   gnd
AD25  USB1Clk   bp2550_a   0.4   10.3n   2.6p
AD26  USB2RxErr   bp2535_b   0.6   15.1n   2.0p
AE01  GND   gnd
AE02  GND   gnd
AE03  MemData16   bsstl2c2_a   0.6   14.7n   2.6p
AE04  MemSelfRef   bp2550_a   0.6   12.3n   2.2p
AE05  DM0   bsstl2c2_a   0.5   11.9n   2.1p
AE06  SVREF2B   power
AE07  MemData13   bsstl2c2t_a   0.5   11.5n   1.9p
AE08  MemData11   bsstl2c2t_a   0.5   11.2n   2.1p
AE09  MemData08   bsstl2c2_a   0.5   10.8n   1.9p
AE10  MemData05   bsstl2c2_a   0.5   11.1n   1.8p
AE11  MemData03   bsstl2c2_a   0.5   10.2n   1.8p
AE12  MemData00   bsstl2c2_a   0.4   10.1n   1.7p
AE13  MemClkOut0_N   bsstl2diff_pm_a   0.5   11.4n   1.6p
AE14  SAVDD   power
AE15  TrcTS6   bp2550_a   0.6   12.8n   1.9p
AE16  EMCMDClk   bp2550_a   0.5   10.1n   1.8p
AE17  AGND   gnd
AE18  SysReset_N   bp2550_a   0.6   11.4n   2.1p
AE19  SysClk   ip25t_a   0.5   11.6n   2.2p
AE20  EMCRxD1   bp2550_a   0.5   11.2n   2.1p
AE21  TrcBS0   bp2550_a   0.5   12.2n   1.9p
AE22  USB2DO1   bp2550t_a   0.5   11.9n   2.2p
AE23  USB2DI1   bp2550_a   0.6   12.2n   2.3p
AE24  TrcTS1   bp2550_a   0.5   12.7n   2.5p
AE25  GND   gnd
AE26  USB2DI4   bp2550_a   0.6   13.5n   2.1p
AF01  GND   gnd
AF02  MemData18   bsstl2c2_a   0.6   15.1n   2.3p
AF03  BA0   bsstl2c2_a   0.6   13.6n   2.6p
AF04  BA1   bsstl2c2_a   0.6   13.0n   2.1p
AF05  ClkEn   bsstl2c2_a   0.6   12.7n   2.1p
AF06  GND   gnd
AF07  DM8   bsstl2c2_a   0.5   12.8n   2.1p
AF08  MemData10   bsstl2c2_a   0.5   12.1n   2.0p
AF09  MemData07   bsstl2c2_a   0.5   11.8n   1.7p
AF10  MemData04   bsstl2c2_a   0.5   11.7n   1.9p
AF11  GND   gnd
AF12  MemClkOut0   bsstl2diff_pm_a   0.5   11.1n   1.8p
AF13  EMCTxD1   bp2550_a   0.5   11.6n   1.8p
AF14  EMCTxD2   bp2550_a   0.5   10.9n   1.8p
AF15  SAGND   gnd
AF16  GND   gnd
AF17  EMCDV   bp2550_a   0.5   11.3n   1.8p
AF18  EMCTxErr   bp2550t_a   0.5   12.1n   2.0p
AF19  EMCRxClk   bp2550_a   0.5   12.2n   1.7p
AF20  EMCTxEn   bp2550t_a   0.5   11.6n   2.1p
AF21  GND   gnd
AF22  TrcES4   bp2550_a   0.6   13.1n   2.2p
AF23  USB2DO3   bp2550t_a   0.6   13.0n   2.3p
AF24  USB2DI2   bp2550t_a   0.6   13.3n   2.5p
AF25  GND   gnd
AF26  GND   gnd
[Diff Pin]  inv_pin  vdiff  tdelay_typ  tdelay_min  tdelay_max
  R23   R24   NA   0   0   0
  W25   W26   NA   0   0   0
 AF12   AE13   NA   0   0   0
| [File]   bpcix3_a.ibs
| [File Rev]   1.4
| [Date]   Fri Sep  6 21:07:23 EDT 2002
| [Source]   File originated at IMD in Burlington, VT USA
[Model Selector]   bpcix3_a
bpcix3_a_pci   PCI Application
bpcix3_a_pcix   PCI-X Application
| [File]   bpcix3t_a.ibs
| [File Rev]   1.4
| [Date]   Fri Sep  6 21:14:50 EDT 2002
| [Source]   File originated at IMD in Burlington, VT USA
[Model Selector]   bpcix3t_a
bpcix3t_a_pci   PCI Application
bpcix3t_a_pcix   PCI-X Application
| [File]   busb5_pm_a.ibs
| [File Rev]   1.4
| [Date]   Fri Oct 10 13:58:57 EDT 2003
| [Source]   File originated at IMD in Burlington, VT USA
[Model Selector]   busb5_pm_a
busb5_pm_a_low   Lowspeed Mode
busb5_pm_a_high   Highspeed Mode
| Models and submodels in the file (87): bp2535_a (I/O), Up.bp2535_a (Dynamic_clamp), Dn.bp2535_a (Dynamic_clamp), bp2535_b (I/O), Up.bp2535_b (Dynamic_clamp), Dn.bp2535_b (Dynamic_clamp), bp2535t_b (I/O), Up.bp2535t_b (Dynamic_clamp), Dn.bp2535t_b (Dynamic_clamp), bp2550_a (I/O), Up.bp2550_a (Dynamic_clamp), Dn.bp2550_a (Dynamic_clamp), bp2550t_a (I/O), Up.bp2550t_a (Dynamic_clamp), Dn.bp2550t_a (Dynamic_clamp), bpcix3_a_pci (I/O), Up.bpcix3_a.pci (Dynamic_clamp), Dn.bpcix3_a.pci (Dynamic_clamp), bpcix3_a_pcix (I/O), Up.bpcix3_a.pcix (Dynamic_clamp), Dn.bpcix3_a.pcix (Dynamic_clamp), bpcix3t_a_pci (I/O), Up.bpcix3t_a.pci (Dynamic_clamp), Dn.bpcix3t_a.pci (Dynamic_clamp), bpcix3t_a_pcix (I/O), Up.bpcix3t_a.pcix (Dynamic_clamp), Dn.bpcix3t_a.pcix (Dynamic_clamp), bsstl2c2_a (I/O), Up.bsstl2c2_a (Dynamic_clamp), Dn.bsstl2c2_a (Dynamic_clamp), bsstl2c2t_a (I/O), Up.bsstl2c2t_a (Dynamic_clamp), Dn.bsstl2c2t_a (Dynamic_clamp), bsstl2diff_pm_a (I/O), Up.bsstl2diff_pm_a (Dynamic_clamp), Dn.bsstl2diff_pm_a (Dynamic_clamp), bt3335_pm_a (I/O), Up.bt3335_pm_a (Dynamic_clamp), Dn.bt3335_pm_a (Dynamic_clamp), bt3335_pm_b (I/O), Up.bt3335_pm_b (Dynamic_clamp), Dn.bt3335_pm_b (Dynamic_clamp), bt3335t_pm_a (I/O), Up.bt3335t_pm_a (Dynamic_clamp), Dn.bt3335t_pm_a (Dynamic_clamp), bt3335t_pm_b (I/O), Up.bt3335t_pm_b (Dynamic_clamp), Dn.bt3335t_pm_b (Dynamic_clamp), bt3350_pm_a (I/O), Up.bt3350_pm_a (Dynamic_clamp), Dn.bt3350_pm_a (Dynamic_clamp), bt3350pu_pm_a (I/O), Up.bt3350pu_pm_a (Dynamic_clamp), Dn.bt3350pu_pm_a (Dynamic_clamp), bt3350t_pm_a (I/O), Up.bt3350t_pm_a (Dynamic_clamp), Dn.bt3350t_pm_a (Dynamic_clamp), busb5_pm_a_low (I/O), Up.busb5_pm_a.low (Dynamic_clamp), Dn.busb5_pm_a.low (Dynamic_clamp), busb5_pm_a_high (I/O), Up.busb5_pm_a.high (Dynamic_clamp), Dn.busb5_pm_a.high (Dynamic_clamp), ip25d1t_a (Input), Up.ip25d1t_a (Dynamic_clamp), Dn.ip25d1t_a (Dynamic_clamp), ip25ltt_a (Input), Up.ip25ltt_a (Dynamic_clamp), Dn.ip25ltt_a (Dynamic_clamp), ip25mct_a (Input), Up.ip25mct_a (Dynamic_clamp), Dn.ip25mct_a (Dynamic_clamp), ip25ret_a (Input), Up.ip25ret_a (Dynamic_clamp), Dn.ip25ret_a (Dynamic_clamp), ip25rit_a (Input), Up.ip25rit_a (Dynamic_clamp), Dn.ip25rit_a (Dynamic_clamp), ip25t_a (Input), Up.ip25t_a (Dynamic_clamp)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
