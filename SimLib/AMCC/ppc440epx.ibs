|   PPC440EPx IBIS Model
|   Preliminary
[IBIS Ver]   3.2
[File Name]   ppc440epx.ibs
[File Rev]   1.1
[Date]   September 22, 2006
[Source]   Applied Micro Circuits Corporation
[Notes]   Release Notes
Version   Date
  1.0   26-JUL-06  PPC440EPx Model, Rev A (1.0) 400MHz (35mm TE-EPBGA package)
  1.1   22-SEP-06   Added 2.5 models for DDR I/O
[Disclaimer]   This IBIS model is provided on an "AS IS" basis and there is
   absolutely no warranty with respect to the information
   contained herein.
[Copyright]   Copyright 2006, AMCC. All Rights Reserved
[Component]   PPC440EPx-NTA400T
[Manufacturer]  AMCC
[Package]
|   typ   min   max
R_pkg   0.3300   0.2800   0.3900
L_pkg   10.7000nH   8.5000nH   13.0000nH
C_pkg   2.3000pF   2.0000pF   2.6000pF
[Pin] signal_name   model_name   R_pin   L_pin   C_pin
 A01  GND   gnd
 A02  GND   gnd
 A03  GND   gnd
 A04  USB2RxErr   bt3350_pm_a   0.546   12.797n   1.375p
 A05  USB2Clk   bt3350_pm_a   0.598   13.853n   1.775p
 A06  TRST_N   bt3350pu_pm_a   0.583   13.789n   1.042p
 A07  PerClk   bt3350_pm_a   0.540   13.451n   1.256p
 A08  PerCS5_N   bt3350_pm_a   0.540   12.327n   0.947p
 A09  PerCS4_N   bt3350t_pm_a   0.519   12.141n   0.938p
 A10  PerData13   bt3350_pm_a   0.540   12.419n   0.816p
 A11  PerData08   bt3350_pm_a   0.525   12.093n   0.872p
 A12  PerData06   bt3350_pm_a   0.517   11.857n   0.894p
 A13  PerData02   bt3350_pm_a   0.506   11.775n   0.841p
 A14  PerRW_N   bt3350_pm_a   0.451   10.701n   0.968p
 A15  PerWBE0_N   bt3350_pm_a   0.443   10.838n   1.108p
 A16  NFWEn_N   bt3350_pm_a   0.485   11.362n   0.920p
 A17  NFRdyBusy_N   bt3350_pm_a   0.464   11.183n   0.754p
 A18  NFCLE   bt3350_pm_a   0.459   10.986n   0.860p
 A19  PerAddr28   bt3350_pm_a   0.483   11.621n   0.893p
 A21  PerAddr22   bt3350t_pm_a   0.467   11.443n   0.944p
 A22  PerAddr18   bt3350t_pm_a   0.458   11.683n   1.164p
 A23  PerAddr15   bt3350_pm_a   0.488   11.624n   0.958p
 A24  PerAddr13   bt3350t_pm_a   0.470   11.324n   1.052p
 A25  PerAddr08   bt3350_pm_a   0.528   12.373n   0.918p
 A26  PerAddr04   bt3350_pm_a   0.499   12.176n   1.081p
 A27  UARTSerClk   bt3350_pm_a   0.558   12.631n   1.666p
 A28  GND   gnd
 A29  UART0_CTS_N   bt3350_pm_a   0.587   13.313n   0.930p
 A30  PCIAD01   bpcix3_a   0.594   13.622n   1.024p
 A31  PCIAD03   bpcix3_a   0.582   13.665n   1.361p
 A32  GND   gnd
 A33  GND   gnd
 A34  GND   gnd
 B01  GND   gnd
 B02  GND   gnd
 B03  GND   gnd
 B04  GND   gnd
 B05  OVDD   power
 B06  USB2TxRdy   it33repdt_pm_a   0.547   12.646n   0.916p
 B07  PerBLast_N   bt3350_pm_a   0.536   12.742n   1.111p
 B08  GND   gnd
 B09  PerCS1_N   bt3350_pm_a   0.520   11.797n   0.940p
 B10  PerData14   bt3350_pm_a   0.515   11.563n   0.866p
 B11  PerData10   bt3350_pm_a   0.473   10.860n   0.922p
 B12  OVDD   power
 B13  PerData03   bt3350_pm_a   0.451   10.494n   0.898p
 B14  PerOE_N   bt3350_pm_a   0.452   10.341n   0.811p
 B15  PerWBE1_N   bt3350_pm_a   0.447   10.247n   0.861p
 B16  GND   gnd
 B17  NFALE   bt3350_pm_a   0.454   10.516n   0.930p
 B18  PerAddr31   bt3350_pm_a   0.424   10.253n   1.015p
 B19  GND   gnd
 B20  PerAddr25   bt3350_pm_a   0.458   11.029n   0.969p
 B21  PerAddr21   bt3350_pm_a   0.464   11.104n   0.873p
 B22  TDO   bt3350_pm_a   0.458   11.143n   1.110p
 B23  OVDD   power
 B24  PerAddr11   bt3350_pm_a   0.476   10.933n   0.881p
 B25  PerAddr07   bt3350_pm_a   0.501   11.505n   0.894p
 B26  GND   gnd
 B27  GND   gnd
 B28  UART0_RI_N   bt3350_pm_a   0.556   12.320n   0.977p
 B29  UART0_RTS_N   bt3350t_pm_a   0.547   12.358n   0.949p
 B30  OVDD   power
 B31  GND   gnd
 B32  GND   gnd
 B33  GND   gnd
 B34  GND   gnd
 C01  USB2DO1   bt3365_pm_a   0.559   13.119n   1.427p
 C02  GND   gnd
 C03  GND   gnd
 C04  GND   gnd
 C05  USB2Susp   bt3350t_pm_a   0.468   10.942n   1.276p
 C06  USB2TxVal   bt3350_pm_a   0.526   12.209n   1.123p
 C07  PerErr   bt3350t_pm_a   0.488   11.586n   1.078p
 C08  USB2RxVal   it33put_pm_a   0.509   12.235n   1.598p
 C09  TestEn   it33tepdt_pm_a   0.483   11.427n   1.690p
 C10  PerData15   bt3350t_pm_a   0.456   10.464n   0.944p
 C11  PerData11   bt3350_pm_a   0.468   10.660n   0.892p
 C12  PerData07   bt3350_pm_a   0.438   9.741n   0.958p
 C13  PerData04   bt3350t_pm_a   0.410   9.604n   1.111p
 C14  PerData00   bt3350t_pm_a   0.394   9.245n   0.958p
 C15  PerWBE2_N   bt3350_pm_a   0.415   9.495n   0.848p
 C17  PerReady   bt3350_pm_a   0.422   9.658n   1.045p
 C18  PerAddr30   bt3350_pm_a   0.399   9.424n   0.863p
 C19  PerAddr27   bt3350_pm_a   0.394   9.592n   1.047p
 C20  PerAddr24   bt3350_pm_a   0.431   10.176n   0.902p
 C21  PerAddr20   bt3350_pm_a   0.400   9.865n   0.954p
 C22  PerAddr17   bt3350_pm_a   0.423   9.805n   1.009p
 C23  PerAddr14   bt3350_pm_a   0.405   9.547n   1.013p
 C24  PerAddr09   bt3350_pm_a   0.443   10.126n   0.907p
 C25  PerAddr06   bt3350t_pm_a   0.439   10.298n   0.983p
 C26  PerAddr02   bt3350_pm_a   0.467   11.063n   1.067p
 C27  UART0_Rx   it33t_pm_a   0.492   11.287n   1.228p
 C28  UART0_DCD_N   bt3350_pm_a   0.526   11.600n   0.934p
 C29  UART0_DSR_N   bt3350_pm_a   0.522   11.994n   1.131p
 C30  PCIAD02   bpcix3t_a   0.519   11.759n   1.120p
 C31  GND   gnd
 C32  GND   gnd
 C33  GND   gnd
 C34  GND   gnd
 D01  USB2DO4   bt3365_pm_a   0.611   13.719n   0.981p
 D02  USB2DO2   bt3365_pm_a   0.565   12.963n   1.184p
 D03  GND   gnd
 D04  GND   gnd
 D05  GND   gnd
 D06  ExtReset_N   bt3350_pm_a   0.504   11.731n   1.487p
 D07  USB2RxAct   it33rit_pm_a   0.462   10.625n   1.391p
 D08  PerCS3_N   bt3350_pm_a   0.468   10.701n   1.056p
 D09  PerCS2_N   bt3350_pm_a   0.442   9.802n   0.943p
 D10  PerCS0_N   bt3350_pm_a   0.453   10.141n   0.855p
 D11  PerData12   bt3350t_pm_a   0.415   9.490n   0.973p
 D12  PerData09   bt3350t_pm_a   0.380   8.570n   1.025p
 D13  PerData05   bt3350_pm_a   0.400   8.873n   0.965p
 D14  PerData01   bt3350_pm_a   0.392   8.845n   0.923p
 D15  PerWBE3_N   bt3350_pm_a   0.380   8.692n   0.940p
 D17  NFREn_N   bt3350_pm_a   0.416   8.999n   1.198p
 D18  PerAddr29   bt3350_pm_a   0.400   9.138n   0.833p
 D19  PerAddr26   bt3350_pm_a   0.391   9.098n   0.963p
 D20  PerAddr23   bt3350_pm_a   0.383   8.984n   0.925p
 D21  PerAddr19   bt3350_pm_a   0.381   9.196n   0.925p
 D22  PerAddr16   bt3350_pm_a   0.367   8.619n   1.041p
 D23  PerAddr12   bt3350_pm_a   0.399   9.270n   0.976p
 D24  PerAddr10   bt3350_pm_a   0.384   9.012n   1.007p
 D25  PerAddr05   bt3350_pm_a   0.432   10.014n   0.999p
 D26  PerAddr03   bt3350_pm_a   0.421   10.138n   1.362p
 D27  UART0_Tx   bt3350_pm_a   0.491   10.855n   1.009p
 D28  UART0_DTR_N   bt3350t_pm_a   0.481   10.631n   0.966p
 D29  PCIAD00   bpcix3_a   0.496   11.449n   1.188p
 D30  GND   gnd
 D31  GND   gnd
 D32  GND   gnd
 D33  GND   gnd
 D34  PCIAD04   bpcix3_a   0.582   13.515n   1.297p
 E01  USB2DO5   bt3365_pm_a   0.586   13.197n   0.928p
 E02  OVDD   power
 E03  USB2DO0   bt3365_pm_a   0.468   10.982n   1.323p
 E04  USB2DO3   bt3365_pm_a   0.463   10.530n   1.155p
 E05  GND   gnd
 E06  OVDD   power
 E07  OVDD   power
 E08  GND   gnd
 E09  OVDD   power
 E10  GND   gnd
 E11  VDD   power
 E12  VDD   power
 E13  VDD   power
 E14  VDD   power
 E15  VDD   power
 E16  GND   gnd
 E17  OVDD   power
 E18  GND   gnd
 E19  GND   gnd
 E20  VDD   power
 E21  VDD   power
 E22  VDD   power
 E23  VDD   power
 E24  VDD   power
 E25  GND   gnd
 E26  OVDD   power
 E27  GND   gnd
 E28  OVDD   power
 E29  OVDD   power
 E30  GND   gnd
 E31  GND   gnd
 E32  Halt_N   it33d2put_pm_a   0.526   11.144n   1.964p
 E33  OVDD   power
 E34  PCIAD06   bpcix3_a   0.589   13.692n   1.112p
 F01  USB2DI1   bt3365_pm_a   0.594   13.252n   0.849p
 F02  USB2DI0   bt3365_pm_a   0.545   12.276n   0.963p
 F03  USB2DO7   bt3365_pm_a   0.527   11.849n   1.005p
 F04  USB2DO6   bt3365_pm_a   0.504   11.162n   0.977p
 F05  OVDD   power
 F30  OVDD   power
 F31  PCIAD05   bpcix3_a   0.475   10.882n   1.110p
 F32  PCIAD07   bpcix3_a   0.519   11.898n   1.015p
 F33  PCIAD08   bpcix3t_a   0.542   12.451n   0.981p
 F34  PCIAD09   bpcix3_a   0.581   13.584n   0.994p
 G01  USB2DI5   bt3365_pm_a   0.582   12.904n   0.891p
 G02  USB2DI4   bt3365_pm_a   0.544   11.983n   0.887p
 G03  USB2DI2   bt3365_pm_a   0.513   11.252n   0.896p
 G04  USB2DI3   bt3365_pm_a   0.498   10.862n   0.897p
 G05  OVDD   power
 G30  OVDD   power
 G31  PCIAD10   bpcix3_a   0.468   11.215n   1.191p
 G32  PCIC0   bpcix3t_a   0.494   11.566n   1.028p
 G33  PCIAD11   bpcix3t_a   0.528   12.283n   0.981p
 G34  PCIAD12   bpcix3_a   0.566   13.400n   0.930p
 H01  GND   gnd
 H02  GND   gnd
 H03  USB2DI7   bt3365_pm_a   0.493   11.367n   1.180p
 H04  USB2DI6   bt3365_pm_a   0.470   10.733n   1.173p
 H05  GND   gnd
 H30  GND   gnd
 H31  PCIAD13   bpcix3_a   0.466   10.732n   1.008p
 H32  PCIAD14   bpcix3_a   0.493   11.376n   1.003p
 H33  GND   gnd
 H34  PCIAD15   bpcix3_a   0.535   12.732n   1.016p
 J03  UAGND   gnd   0.435   10.249n   1.321p
 J04  UAVDD   power   0.405   9.636n   1.608p
 J05  OVDD   power
 J30  OVDD   power
 J31  PCIC1   bpcix3t_a   0.456   10.163n   0.899p
 J32  PCIPar   bpcix3_a   0.491   11.220n   0.952p
 J33  PCIPErr_N   bpcix3_a   0.531   11.962n   0.874p
 J34  PCISErr_N   bpcix3t_a   0.542   12.435n   0.873p
 K01  UAGND   gnd   0.455   11.424n   1.164p
 K02  TMS   bt3350pu_pm_a   0.505   11.358n   0.943p
 K03  TDI   bt3350pu_pm_a   0.478   10.553n   1.120p
 K04  UAGND   gnd   0.399   9.494n   1.276p
 K05  GND   gnd
 K30  GND   gnd
 K31  PCIStop_N   bpcix3_a   0.448   9.940n   0.924p
 K32  PCIDevSel_N   bpcix3_a   0.456   10.216n   0.907p
 K33  PCIIRDY_N   bpcix3_a   0.504   11.362n   0.887p
 K34  PCITRDY_N   bpcix3_a   0.524   12.135n   0.851p
 L01  UAVDD   power   0.448   11.128n   1.083p
 L02  UAVDD   power   0.436   10.518n   1.029p
 L04  UAVDD   power   0.390   9.285n   1.112p
 L05  VDD   power
 L30  VDD   power
 L31  PCIAD16   bpcix3_a   0.426   9.538n   0.881p
 L32  PCIFrame_N   bpcix3t_a   0.436   10.015n   0.957p
 L33  PCIAD17   bpcix3_a   0.471   11.001n   1.006p
 L34  PCIC2   bpcix3_a   0.486   11.556n   1.009p
 M01  UAGND   gnd   0.439   10.892n   1.249p
 M02  OVDD   power
 M03  USB2XcvrSel   bt3350_pm_a   0.455   10.087n   0.957p
 M04  UAGND   gnd   0.386   9.036n   1.071p
 M05  VDD   power
 M30  VDD   power
 M31  PCIAD19   bpcix3_a   0.400   9.200n   1.025p
 M32  PCIAD18   bpcix3t_a   0.416   9.650n   1.046p
 M33  OVDD   power
 M34  PCIAD20   bpcix3_a   0.486   11.700n   1.010p
 N01  GND   gnd
 N04  GND   gnd
 N05  VDD   power
 N13  GND   gnd
 N14  OVDD   power
 N15  GND   gnd
 N16  VDD   power
 N17  GND   gnd
 N18  GND   gnd
 N19  VDD   power
 N20  GND   gnd
 N21  OVDD   power
 N22  GND   gnd
 N30  VDD   power
 N31  PCIAD21   bpcix3_a   0.391   9.080n   1.075p
 N32  PCIAD23   bpcix3_a   0.421   9.752n   0.961p
 N33  PCIAD22   bpcix3t_a   0.441   10.487n   0.995p
 N34  PCIC3   bpcix3_a   0.474   11.249n   0.966p
 P01  USB2LS1   it33ltput_pm_a   0.489   11.321n   0.840p
 P02  TCK   bt3350pu_pm_a   0.467   10.796n   1.092p
 P03  TmrClk   bt3350_pm_a   0.444   10.080n   1.350p
 P04  USB2TermSel   bt3350_pm_a   0.406   9.398n   1.279p
 P05  VDD   power
 P13  OVDD   power
 P14  GND   gnd
 P15  GND   gnd
 P17  GND   gnd
 P16  VDD   power
 P18  GND   gnd
 P19  VDD   power
 P20  GND   gnd
 P21  GND   gnd
 P22  OVDD   power
 P30  VDD   power
 P31  PCIAD24   bpcix3_a   0.389   8.918n   0.972p
 P32  PCIAD26   bpcix3_a   0.416   9.640n   0.903p
 P33  PCIAD25   bpcix3t_a   0.431   10.172n   0.925p
 P34  PCIAD27   bpcix3_a   0.476   11.106n   0.858p
 R01  MemData59   bddr251843_pm_a   0.462   11.116n   1.030p
 R02  USB2LS0   it33d1put_pm_a   0.481   10.595n   1.086p
 R03  USB2OM0   bt3350_pm_a   0.460   10.116n   1.003p
 R04  USB2OM1   bt3350t_pm_a   0.393   8.948n   0.977p
 R05  VDD   power
 R13  GND   gnd
 R14  GND   gnd
 R15  GND   gnd
 R16  GND   gnd
 R17  GND   gnd
 R18  GND   gnd
 R19  GND   gnd
 R20  GND   gnd
 R21  GND   gnd
 R22  GND   gnd
 R30  VDD   power
 R31  PCIAD28   bpcix3t_a   0.372   8.459n   0.937p
 R32  PCIAD29   bpcix3_a   0.411   9.375n   0.872p
 R33  PCIAD30   bpcix3_a   0.444   10.237n   0.892p
 R34  PCIAD31   bpcix3_a   0.471   11.077n   0.883p
 T01  MemData62   bddr251843_pm_a   0.463   11.123n   0.968p
 T02  GND   gnd
 T03  MemData63   bddr251843_pm_a   0.433   10.033n   0.801p
 T04  MemData58   bddr251843_pm_a   0.405   9.113n   0.846p
 T05  GND   gnd
 T13  VDD   power
 T14  VDD   power
 T15  GND   gnd
 T16  GND   gnd
 T17  GND   gnd
 T18  GND   gnd
 T19  GND   gnd
 T20  GND   gnd
 T21  VDD   power
 T22  VDD   power
 T30  GND   gnd
 T31  PCIIDSel   bpcix3t_a   0.385   8.822n   0.973p
 T32  IRQ9   bt3350_pm_a   0.443   10.061n   1.155p
 T33  GND   gnd
 T34  IRQ8   bt3350_pm_a   0.476   11.175n   1.041p
 U01  MemData56   bddr251843_pm_a   0.464   11.474n   0.915p
 U02  MemData57   bddr251843_pm_a   0.457   10.721n   0.870p
 U03  DM7   bddr251843t_pm_a   0.398   9.750n   0.931p
 U04  DQS7   bddr251843_pm_a   0.394   9.055n   0.905p
 U05  GND   gnd
 U13  GND   gnd
 U14  GND   gnd
 U15  GND   gnd
 U16  GND   gnd
 U17  GND   gnd
 U18  GND   gnd
 U19  GND   gnd
 U20  GND   gnd
 U21  GND   gnd
 U22  GND   gnd
 U30  OVDD   power
 U31  PCIReq1_N   bpcix3_a   0.396   9.057n   0.968p
 U32  IRQ7   bt3350_pm_a   0.417   9.658n   0.900p
 U33  IRQ6   bt3350_pm_a   0.461   10.681n   0.781p
 U34  IRQ3   bt3350_pm_a   0.485   11.579n   0.923p
 V01  MemData61   bddr251843_pm_a   0.487   11.862n   0.740p
 V02  MemData60   bddr251843_pm_a   0.456   10.901n   0.845p
 V03  MemData51   bddr251843_pm_a   0.426   9.900n   0.837p
 V04  MemData50   bddr251843_pm_a   0.374   8.521n   0.903p
 V05  SOVDD   power
 V13  GND   gnd
 V14  GND   gnd
 V15  GND   gnd
 V16  GND   gnd
 V17  GND   gnd
 V18  GND   gnd
 V19  GND   gnd
 V20  GND   gnd
 V21  GND   gnd
 V22  GND   gnd
 V30  GND   gnd
 V31  PCIReq3_N   bpcix3_a   0.397   9.207n   0.898p
 V32  IRQ4   bt3350_pm_a   0.413   9.741n   1.252p
 V33  PCIReq2_N   bpcix3_a   0.456   10.670n   0.834p
 V34  PCIReq0_N   bpcix3_a   0.485   11.537n   0.900p
 W01  MemData55   bddr251843_pm_a   0.461   11.126n   0.871p
 W02  GND   gnd
 W03  MemData54   bddr251843_pm_a   0.431   9.877n   0.885p
 W04  DQS6   bddr251843_pm_a   0.404   9.113n   0.869p
 W05  GND   gnd
 W13  VDD   power
 W14  VDD   power
 W15  GND   gnd
 W16  GND   gnd
 W17  GND   gnd
 W18  GND   gnd
 W19  GND   gnd
 W20  GND   gnd
 W21  VDD   power
 W22  VDD   power
 W30  GND   gnd
 W31  PCIReq5_N   bpcix3_a   0.395   8.946n   0.922p
 W32  PCIReq4_N   bpcix3_a   0.430   10.006n   0.910p
 W33  GND   gnd
 W34  IRQ5   it33mct_pm_a   0.497   11.122n   1.270p
 Y01  DM6   bddr251843t_pm_a   0.466   11.017n   0.953p
 Y02  MemData49   bddr251843_pm_a   0.462   10.804n   0.836p
 Y03  MemData48   bddr251843_pm_a   0.433   9.852n   0.938p
 Y04  SVREF1A   power
 Y05  VDD   power
 Y13  GND   gnd
 Y14  GND   gnd
 Y15  GND   gnd
 Y16  GND   gnd
 Y17  GND   gnd
 Y18  GND   gnd
 Y19  GND   gnd
 Y20  GND   gnd
 Y21  GND   gnd
 Y22  GND   gnd
 Y30  VDD   power
 Y31  PCIGnt3_N   bpcix3_a   0.395   8.818n   0.949p
 Y32  PCIGnt2_N   bpcix3t_a   0.433   9.716n   0.939p
 Y33  PCIGnt1_N   bpcix3_a   0.477   10.796n   0.867p
 Y34  PCIGnt0_N   bpcix3_a   0.502   11.772n   0.827p
 AA01 MemData53   bddr251843_pm_a   0.496   11.895n   0.946p
 AA02 MemData52   bddr251843_pm_a   0.468   11.013n   0.836p
 AA03 MemData43   bddr251843_pm_a   0.411   9.613n   0.974p
 AA04 MemData42   bddr251843_pm_a   0.405   9.348n   0.910p
 AA05 VDD   power
 AA13 SOVDD   power
 AA14 GND   gnd
 AA15 GND   gnd
 AA16 VDD   power
 AA17 GND   gnd
 AA18 GND   gnd
 AA19 VDD   power
 AA20 GND   gnd
 AA21 GND   gnd
 AA22 EOVDD   power
 AA30 VDD   power
 AA31 PCIReset_N   bpcix3_a   0.388   8.712n   1.180p
 AA32 PCIClk   bpcix3_a   0.420   9.496n   1.288p
 AA33 PCIGnt4_N   bpcix3t_a   0.443   10.176n   1.173p
 AA34 PCIGnt5_N   bpcix3_a   0.483   11.376n   0.877p
 AB01 MemData46   bddr251843_pm_a   0.476   11.432n   0.958p
 AB02 MemData47   bddr251843_pm_a   0.471   11.173n   0.904p
 AB03 DM5   bddr251843t_pm_a   0.414   9.874n   1.026p
 AB04 DQS5   bddr251843_pm_a   0.406   9.498n   1.071p
 AB05 VDD   power
 AB13 GND   gnd
 AB14 SOVDD   power
 AB15 GND   gnd
 AB16 VDD   power
 AB17 GND   gnd
 AB18 GND   gnd
 AB19 VDD   power
 AB20 GND   gnd
 AB21 EOVDD   power
 AB22 GND   gnd
 AB30 VDD   power
 AB31 SCPDO   bt3335_pm_a   0.411   8.927n   0.923p
 AB32 IIC0SClk   bt3335_pm_a   0.437   9.610n   0.872p
 AB33 IIC0SData   bt3335t_pm_a   0.447   10.310n   1.044p
 AB34 PCIINT_N   bpcix3t_a   0.470   11.137n   1.098p
 AC01 MemData41   bddr251843_pm_a   0.505   11.912n   0.980p
 AC02 SOVDD   power
 AC03 MemData40   bddr251843_pm_a   0.448   10.252n   0.996p
 AC04 MemData45   bddr251843_pm_a   0.394   9.083n   1.064p
 AC05 VDD   power
 AC30 VDD   power
 AC31 IRQ1   bt3350_pm_a   0.424   9.169n   0.905p
 AC32 SCPDI   bt3335_pm_a   0.432   9.510n   0.936p
 AC33 EOVDD   power
 AC34 SCPClkOut   bt3335_pm_a   0.500   11.363n   0.948p
 AD01 GND   gnd
 AD02 MemData44   bddr251843_pm_a   0.459   10.641n   1.091p
 AD03 MemData35   bddr251843_pm_a   0.457   10.264n   0.983p
 AD04 MemData34   bddr251843_pm_a   0.429   9.623n   0.989p
 AD05 VDD   power
 AD30 VDD   power
 AD31 SysReset_N   bp2550_a   0.474   10.086n   1.522p
 AD32 SysErr   bp2550t_a   0.476   10.246n   0.905p
 AD33 IRQ0   bt3350_pm_a   0.523   11.347n   0.862p
 AD34 IRQ2   bt3350_pm_a   0.539   11.836n   0.888p
 AE01 MemData39   bddr251843_pm_a   0.499   11.647n   1.049p
 AE02 MemData38   bddr251843_pm_a   0.496   11.291n   0.947p
 AE03 DQS4   bddr251843_pm_a   0.465   10.607n   0.952p
 AE04 DM4   bddr251843t_pm_a   0.409   9.435n   1.091p
 AE05 GND   gnd
 AE30 GND   gnd
 AE31 TrcES0   bp2550_a   0.461   9.883n   0.934p
 AE32 TrcBS1   bp2550t_a   0.481   10.383n   0.886p
 AE33 TrcBS2   bp2550_a   0.527   11.428n   0.848p
 AE34 TrcBS0   bp2550_a   0.558   12.225n   0.852p
 AF01 MemData33   bddr251843_pm_a   0.531   12.491n   0.986p
 AF02 MemData37   bddr251843_pm_a   0.478   11.259n   1.097p
 AF03 MemData32   bddr251843_pm_a   0.467   10.936n   1.055p
 AF04 SVREF2A   power
 AF05 SOVDD   power
 AF30 EOVDD   power
 AF31 TrcES4   bp2550_a   0.466   10.150n   0.919p
 AF32 TrcES3   bp2550_a   0.497   10.884n   0.894p
 AF33 TrcES2   bp2550t_a   0.515   11.314n   0.917p
 AF34 TrcES1   bp2550_a   0.544   12.176n   0.881p
 AG01 MemODT1   bddr251843t_pm_a   0.512   12.335n   1.120p
 AG02 GND   gnd
 AG03 MemData36   bddr251843_pm_a   0.479   11.367n   1.182p
 AG04 MemAddr13   bddr251843_pm_a   0.448   10.728n   1.345p
 AG05 GND   gnd
 AG30 GND   gnd
 AG31 TrcTS1   bp2550t_a   0.458   10.389n   1.075p
 AG32 TrcClk   bp2550_a   0.478   11.225n   1.215p
 AG33 GND   gnd
 AG34 TrcTS0   bp2550_a   0.549   12.595n   1.057p
 AH01 BankSel1_N   bddr251843_pm_a   0.563   12.999n   0.977p
 AH02 BankSel0_N   bddr251843t_pm_a   0.517   11.643n   0.965p
 AH03 MemODT0   bddr251843_pm_a   0.513   11.399n   0.904p
 AH04 CAS_N   bddr251843t_pm_a   0.472   10.422n   0.970p
 AH05 SOVDD   power
 AH30 EOVDD   power
 AH31 TrcTS6   bp2550_a   0.477   10.518n   1.122p
 AH32 TrcTS4   bp2550_a   0.524   11.207n   0.954p
 AH33 TrcTS2   bp2550_a   0.538   12.211n   1.087p
 AH34 TrcTS3   bp2550_a   0.560   12.680n   0.914p
 AJ01 GND   gnd
 AJ02 WE_N   bddr251843_pm_a   0.549   12.374n   1.007p
 AJ03 BA0   bddr251843t_pm_a   0.500   11.243n   1.036p
 AJ04 RAS_N   bddr251843_pm_a   0.494   11.028n   1.250p
 AJ05 SOVDD   power
 AJ30 EOVDD   power
 AJ31 GMCRxDV   bp2550_a   0.497   11.131n   1.586p
 AJ32 GMCCD   bp2550_a   0.530   11.657n   1.574p
 AJ33 GMCRefClk   ip25t_a   0.549   12.059n   1.612p
 AJ34 TrcTS5   bp2550t_a   0.568   12.538n   1.476p
 AK01 MemClkOut_N   bddr251843diff_pm_a   0.592   13.329n   1.453p
 AK02 SOVDD   power
 AK03 BA1   bddr251843_pm_a   0.518   12.228n   1.554p
 AK04 GND   gnd
 AK05 GND   gnd
 AK06 SOVDD   power
 AK07 SOVDD   power
 AK08 GND   gnd
 AK09 SOVDD   power
 AK10 GND   gnd
 AK11 VDD   power
 AK12 VDD   power
 AK13 VDD   power
 AK14 VDD   power
 AK15 VDD   power
 AK16 GND   gnd
 AK17 GND   gnd
 AK18 SOVDD   power
 AK19 GND   gnd
 AK20 VDD   power
 AK21 VDD   power
 AK22 VDD   power
 AK23 VDD   power
 AK24 VDD   power
 AK25 GND   gnd
 AK26 EOVDD   power
 AK27 GND   gnd
 AK28 EOVDD   power
 AK29 EOVDD   power
 AK30 GND   gnd
 AK31 GND   gnd
 AK32 GMCCrs   bp2550_a   0.543   11.828n   1.745p
 AK33 EOVDD   power
 AK34 GMCMDIO   bp2550_a   0.561   12.828n   1.544p
 AL01 MemClkOut   bddr251843diff_pm_a   0.609   13.748n   1.503p
 AL02 MemAddr10   bddr251843t_pm_a   0.533   12.544n   1.451p
 AL03 GND   gnd
 AL04 GND   gnd
 AL05 GND   gnd
 AL06 GND   gnd
 AL07 MemAddr06   bddr251843_pm_a   0.461   10.575n   1.050p
 AL08 MemAddr11   bddr251843_pm_a   0.429   9.936n   1.127p
 AL09 ECC3   bddr251843_pm_a   0.449   10.087n   1.034p
 AL10 SVREF1B   power
 AL11 ECC1   bddr251843_pm_a   0.384   8.805n   1.025p
 AL12 MemData27   bddr251843_pm_a   0.399   8.946n   0.965p
 AL13 MemData30   bddr251843_pm_a   0.370   8.417n   1.086p
 AL14 DM3   bddr251843t_pm_a   0.369   8.158n   0.940p
 AL15 MemData18   bddr251843_pm_a   0.376   8.244n   0.900p
 AL16 DQS2   bddr251843_pm_a   0.398   8.826n   0.899p
 AL17 MemData20   bddr251843_pm_a   0.374   8.367n   0.914p
 AL18 MemData09   bddr251843_pm_a   0.394   8.821n   0.915p
 AL19 SVREF2B   power
 AL20 MemData03   bddr251843_pm_a   0.388   8.644n   0.918p
 AL21 DM0   bddr251843t_pm_a   0.382   8.558n   0.894p
 AL22 MemData04   bddr251843_pm_a   0.392   8.879n   1.117p
 AL23 RejectPkt1   bp2550_a   0.409   8.581n   0.978p
 AL24 GMCTxD0   bp2550_a   0.415   9.067n   0.985p
 AL25 GMCTxD3   bp2550_a   0.446   9.516n   0.871p
 AL26 GMCTxD5   bp2550_a   0.449   9.689n   1.084p
 AL27 GMCTxClk   bp2550_a   0.470   10.309n   1.350p
 AL28 GMCRxD0   bp2550_a   0.499   10.836n   0.912p
 AL29 GND   gnd
 AL30 GND   gnd
 AL31 GND   gnd
 AL32 GND   gnd
 AL33 GMCRxEr   bp2550_a   0.556   12.599n   1.585p
 AL34 GMCMDClk   bp2550t_a   0.572   12.492n   1.675p
 AM01 GND   gnd
 AM02 GND   gnd
 AM03 GND   gnd
 AM04 GND   gnd
 AM05 MemAddr00   bddr251843t_pm_a   0.487   11.303n   1.245p
 AM06 MemAddr03   bddr251843_pm_a   0.499   11.500n   1.157p
 AM07 MemAddr08   bddr251843t_pm_a   0.469   10.910n   1.092p
 AM08 MemAddr12   bddr251843t_pm_a   0.457   10.672n   1.078p
 AM09 ECC2   bddr251843_pm_a   0.474   10.858n   0.986p
 AM10 ECC6   bddr251843_pm_a   0.460   10.784n   1.050p
 AM11 ECC0   bddr251843_pm_a   0.439   9.939n   1.012p
 AM12 MemData31   bddr251843_pm_a   0.407   9.210n   1.021p
 AM13 DQS3   bddr251843_pm_a   0.432   9.650n   0.901p
 AM14 MemData28   bddr251843_pm_a   0.395   8.888n   0.931p
 AM15 MemData23   bddr251843_pm_a   0.415   9.215n   0.868p
 AM16 MemData16   bddr251843_pm_a   0.404   9.201n   0.959p
 AM17 MemData21   bddr251843_pm_a   0.428   9.617n   0.826p
 AM18 DM1   bddr251843t_pm_a   0.404   9.207n   0.898p
 AM19 DQS1   bddr251843_pm_a   0.427   9.774n   0.962p
 AM20 MemData02   bddr251843_pm_a   0.389   9.010n   0.936p
 AM21 DQS0   bddr251843_pm_a   0.422   9.573n   0.869p
 AM22 MemData05   bddr251843_pm_a   0.423   9.617n   0.931p
 AM23 RejectPkt0   bp2550_a   0.435   9.236n   1.148p
 AM24 GMCTxEr   bp2550_a   0.441   9.653n   0.946p
 AM25 GMCTxD2   bp2550_a   0.460   10.078n   0.816p
 AM26 GMCTxD7   bp2550_a   0.471   10.169n   0.965p
 AM27 GMCGTxClk   bp2550_a   0.481   10.918n   1.347p
 AM28 GMCRxD2   bp2550t_a   0.497   11.156n   1.148p
 AM29 GMCRxD4   bp2550_a   0.525   11.480n   1.059p
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[Model Selector]   bpcix3_a
bpcix3_a_mpa   Multiple Point Application
bpcix3_a_ppa   Point to Point Application
[Model Selector]   bpcix3t_a
bpcix3t_a_mpa   Multiple Point Application
bpcix3t_a_ppa   Point to Point Application
[Model Selector]   bddr251843_pm_a
bddr251843_pm_a_18   Default Mode 1.8  Trerminator off
bddr251843_pm_a_1875   1.8 75ohm termimation at VDD2518/2
bddr251843_pm_a_25   Default Mode 2.5  Trerminator off
bddr251843_pm_a_2575   2.5 75ohm termimation at VDD2518/2
[Model Selector]   bddr251843t_pm_a
bddr251843t_pm_a_18   Default Mode 1.8  Trerminator off
bddr251843t_pm_a1875   1.8 75ohm at termination at VDD2518/2
bddr251843t_pm_a_25   Default Mode 2.5  Trerminator off
bddr251843t_pm_a2575   2.5 75ohm at termination at VDD2518/2
[Model Selector]   bddr251843diff_pm_a
bddr251843diff_pma18   Default Mode 1.8  Trerminator off
bddr251843diff_p1875   1.8 75ohm termination at VDD2518/2
bddr251843diff_pma25   Default Mode 2.5  Trerminator off
bddr251843diff_p2575   2.5 75ohm termination at VDD2518/2
| Models and submodels in the file (78): bp2550_a (I/O), Up.bp2550_a (Dynamic_clamp), Dn.bp2550_a (Dynamic_clamp), ip25t_a (Input), Up.ip25t_a (Dynamic_clamp), Dn.ip25t_a (Dynamic_clamp), bp2550t_a (I/O), Up.bp2550t_a (Dynamic_clamp), Dn.bp2550t_a (Dynamic_clamp), bpcix3_a_mpa (I/O), Up.bpcix3_a.mpa (Dynamic_clamp), Dn.bpcix3_a.mpa (Dynamic_clamp), bpcix3_a_ppa (I/O), Up.bpcix3_a.ppa (Dynamic_clamp), Dn.bpcix3_a.ppa (Dynamic_clamp), bpcix3t_a_mpa (I/O), Up.bpcix3t_a.mpa (Dynamic_clamp), Dn.bpcix3t_a.mpa (Dynamic_clamp), bpcix3t_a_ppa (I/O), Up.bpcix3t_a.ppa (Dynamic_clamp), Dn.bpcix3t_a.ppa (Dynamic_clamp), bt3350_pm_a (I/O), Up.bt3350_pm_a (Dynamic_clamp), Dn.bt3350_pm_a (Dynamic_clamp), bt3350pu_pm_a (I/O), Up.bt3350pu_pm_a (Dynamic_clamp), Dn.bt3350pu_pm_a (Dynamic_clamp), bt3350t_pm_a (I/O), Up.bt3350t_pm_a (Dynamic_clamp), Dn.bt3350t_pm_a (Dynamic_clamp), it33d2put_pm_a (Input), Up.it33d2put_pm_a (Dynamic_clamp), Dn.it33d2put_pm_a (Dynamic_clamp), bt3335_pm_a (I/O), Up.bt3335_pm_a (Dynamic_clamp), Dn.bt3335_pm_a (Dynamic_clamp), bt3335t_pm_a (I/O), Up.bt3335t_pm_a (Dynamic_clamp), Dn.bt3335t_pm_a (Dynamic_clamp), it33mct_pm_a (Input), Up.it33mct_pm_a (Dynamic_clamp), Dn.it33mct_pm_a (Dynamic_clamp), it33tepdt_pm_a (Input), Up.it33tepdt_pm_a (Dynamic_clamp), Dn.it33tepdt_pm_a (Dynamic_clamp), it33t_pm_a (Input), Up.it33t_pm_a (Dynamic_clamp), Dn.it33t_pm_a (Dynamic_clamp), bt3365_pm_a (I/O), Up.bt3365_pm_a (Dynamic_clamp), Dn.bt3365_pm_a (Dynamic_clamp), it33d1put_pm_a (Input), Up.it33d1put_pm_a (Dynamic_clamp), Dn.it33d1put_pm_a (Dynamic_clamp), it33ltput_pm_a (Input), Up.it33ltput_pm_a (Dynamic_clamp), Dn.it33ltput_pm_a (Dynamic_clamp), it33rit_pm_a (Input), Up.it33rit_pm_a (Dynamic_clamp), Dn.it33rit_pm_a (Dynamic_clamp), it33put_pm_a (Input), Up.it33put_pm_a (Dynamic_clamp), Dn.it33put_pm_a (Dynamic_clamp), it33repdt_pm_a (Input), Up.it33repdt_pm_a (Dynamic_clamp), Dn.it33repdt_pm_a (Dynamic_clamp), bddr251843_pm_a_18 (I/O), bddr251843_pm_a_1875 (I/O), bddr251843_pm_a_25 (I/O), bddr251843_pm_a_2575 (I/O), bddr251843t_pm_a_18 (I/O), bddr251843t_pm_a1875 (I/O), bddr251843t_pm_a_25 (I/O), bddr251843t_pm_a2575 (I/O), bddr251843diff_pma18 (I/O), bddr251843diff_p1875 (I/O), bddr251843diff_pma25 (I/O), bddr251843diff_p2575 (I/O)
