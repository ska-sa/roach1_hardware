**/////////////////////////////////////////////////////////////////////////////
**$Date: 2007/11/06 18:10:54 $
**$RCSfile: temperature_settings_slow.ckt,v $
**$Revision: 1.1 $
**//////////////////////////////////////////////////////////////////////////////
**   ____  ____
**  /   /\/   /
** /___/  \  /    Vendor: Xilinx
** \   \   \/     Version : 1.0
**  \   \         Filename : temperature_settings_slow.ckt
**  /   /
** /___/   /\
** \   \  /  \
**  \___\/\___\
**
**                VIRTEX-5 FPGA ROCKETIO SIGNAL INTEGRITY KIT
**
**
** Description : Temperature Settings for slow operating conditions
**//////////////////////////////////////////////////////////////////////////////

.TEMP 100
