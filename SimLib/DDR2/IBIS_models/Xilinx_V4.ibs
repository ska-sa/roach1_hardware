| / 7\'7
| \ \   Xilinx Inc.
| / /
| \_\/.\   IBIS Models for Virtex-4
[IBIS ver]   3.2
[File name]   virtex4.ibs
[File Rev]   1.0
[Date]   Nov. 4, 2004
[Source]   HSPICE simulations
[Notes]   Xilinx IBIS file for Virtex-4 I/O standards.
   All models are preliminary.
   To accurately model package parasitics, please include in
   your simulation a 50-65 ohm transmission line with 10-200ps of
   delay. For additional information, please see this Answer
   Record: http://support.xilinx.com/techdocs/11754.htm
[Disclaimer] The data in this file is derived from SPICE simulations using
                 modeling information extracted from the target process. While
                 a great deal of care has been taken to provide information
                 that is accurate, this model is considered preliminary as it
                 has not been verified by actual silicon measurement. Treat the
                 data in this model as preliminary until actual silicon
                 verification is performed.
[Copyright]   Copyright 2004, Xilinx Inc., All rights reserved
|   Component Virtex-4
[Component]   VIRTEX-4
[Manufacturer]   Xilinx Inc.
[Package]
| Package Parasitics
| variable   typ   min   max
R_pkg   0.1   NA   NA
L_pkg   0.8nH   NA   NA
C_pkg   0.5pF   NA   NA
| Note: Pins are arbitrarily numbered and do not correspond to any
|   specific package pinout. Design-specific pinouts can be created
|   with the Xilinx IBISWriter program.
[Pin]  signal_name   model_name   R_pin   L_pin   C_pin
|   LVTTL programmable drive strength I/Os
1   LVTTL_F_2   LVTTL_F_2   | fast slew, 2mA drive
2   LVTTL_S_2   LVTTL_S_2   | slow slew, 2mA drive
3   LVTTL_F_4   LVTTL_F_4   | fast slew, 4mA drive
4   LVTTL_S_4   LVTTL_S_4   | slow slew, 4mA drive
5   LVTTL_F_6   LVTTL_F_6   | fast slew, 6mA drive
6   LVTTL_S_6   LVTTL_S_6   | slow slew, 6mA drive
7   LVTTL_F_8   LVTTL_F_8   | fast slew, 8mA drive
8`   LVTTL_S_8   LVTTL_S_8   | slow slew, 8mA drive
9   LVTTL_F_12   LVTTL_F_12   | fast slew, 12mA drive
10   LVTTL_S_12   LVTTL_S_12   | slow slew, 12mA drive
11   LVTTL_F_16   LVTTL_F_16   | fast slew, 16mA drive
12   LVTTL_S_16   LVTTL_S_16   | slow slew, 16mA drive
13   LVTTL_F_24   LVTTL_F_24   | fast slew, 24mA drive
14   LVTTL_S_24   LVTTL_S_24   | slow slew, 24mA drive
|   LVCMOS 3.3V programmable drive strength I/Os
15   LVCMOS33_F_2   LVCMOS33_F_2   | fast slew, 2mA drive
16   LVCMOS33_S_2   LVCMOS33_S_2   | slow slew, 2mA drive
17   LVCMOS33_F_4   LVCMOS33_F_4   | fast slew, 4mA drive
18   LVCMOS33_S_4   LVCMOS33_S_4   | slow slew, 4mA drive
19   LVCMOS33_F_6   LVCMOS33_F_6   | fast slew, 6mA drive
20   LVCMOS33_S_6   LVCMOS33_S_6   | slow slew, 6mA drive
21   LVCMOS33_F_8   LVCMOS33_F_8   | fast slew, 8mA drive
22   LVCMOS33_S_8   LVCMOS33_S_8   | slow slew, 8mA drive
23   LVCMOS33_F_12   LVCMOS33_F_12   | fast slew, 12mA drive
24   LVCMOS33_S_12   LVCMOS33_S_12   | slow slew, 12mA drive
25   LVCMOS33_F_16   LVCMOS33_F_16   | fast slew, 16mA drive
26   LVCMOS33_S_16   LVCMOS33_S_16   | slow slew, 16mA drive
27   LVCMOS33_F_24   LVCMOS33_F_24   | fast slew, 24mA drive
28   LVCMOS33_S_24   LVCMOS33_S_24   | slow slew, 24mA drive
|   LVCMOS 2.5V programmable drive strength I/Os
29   LVCMOS25_F_2   LVCMOS25_F_2   | fast slew, 2mA drive
30   LVCMOS25_S_2   LVCMOS25_S_2   | slow slew, 2mA drive
31   LVCMOS25_F_4   LVCMOS25_F_4   | fast slew, 4mA drive
32   LVCMOS25_S_4   LVCMOS25_S_4   | slow slew, 4mA drive
33   LVCMOS25_F_6   LVCMOS25_F_6   | fast slew, 6mA drive
34   LVCMOS25_S_6   LVCMOS25_S_6   | slow slew, 6mA drive
35   LVCMOS25_F_8   LVCMOS25_F_8   | fast slew, 8mA drive
36   LVCMOS25_S_8   LVCMOS25_S_8   | slow slew, 8mA drive
37   LVCMOS25_F_12   LVCMOS25_F_12   | fast slew, 12mA drive
38   LVCMOS25_S_12   LVCMOS25_S_12   | slow slew, 12mA drive
39   LVCMOS25_F_16   LVCMOS25_F_16   | fast slew, 16mA drive
40   LVCMOS25_S_16   LVCMOS25_S_16   | slow slew, 16mA drive
41   LVCMOS25_F_24   LVCMOS25_F_24   | fast slew, 24mA drive
42   LVCMOS25_S_24   LVCMOS25_S_24   | slow slew, 24mA drive
|   LVCMOS 1.8V programmable drive strength I/Os
43   LVCMOS18_F_2   LVCMOS18_F_2   | fast slew, 2mA drive
44   LVCMOS18_S_2   LVCMOS18_S_2   | slow slew, 2mA drive
45   LVCMOS18_F_4   LVCMOS18_F_4   | fast slew, 4mA drive
46   LVCMOS18_S_4   LVCMOS18_S_4   | slow slew, 4mA drive
47   LVCMOS18_F_6   LVCMOS18_F_6   | fast slew, 6mA drive
48   LVCMOS18_S_6   LVCMOS18_S_6   | slow slew, 6mA drive
49   LVCMOS18_F_8   LVCMOS18_F_8   | fast slew, 8mA drive
50   LVCMOS18_S_8   LVCMOS18_S_8   | slow slew, 8mA drive
51   LVCMOS18_F_12   LVCMOS18_F_12   | fast slew, 12mA drive
52   LVCMOS18_S_12   LVCMOS18_S_12   | slow slew, 12mA drive
53   LVCMOS18_F_16   LVCMOS18_F_16   | fast slew, 16mA drive
54   LVCMOS18_S_16   LVCMOS18_S_16   | slow slew, 16mA drive
|   LVCMOS 1.5V programmable drive strength I/Os
55   LVCMOS15_F_2   LVCMOS15_F_2   | fast slew, 2mA drive
56   LVCMOS15_S_2   LVCMOS15_S_2   | slow slew, 2mA drive
57   LVCMOS15_F_4   LVCMOS15_F_4   | fast slew, 4mA drive
58   LVCMOS15_S_4   LVCMOS15_S_4   | slow slew, 4mA drive
59   LVCMOS15_F_6   LVCMOS15_F_6   | fast slew, 6mA drive
60   LVCMOS15_S_6   LVCMOS15_S_6   | slow slew, 6mA drive
61   LVCMOS15_F_8   LVCMOS15_F_8   | fast slew, 8mA drive
62   LVCMOS15_S_8   LVCMOS15_S_8   | slow slew, 8mA drive
63   LVCMOS15_F_12   LVCMOS15_F_12   | fast slew, 12mA drive
64   LVCMOS15_S_12   LVCMOS15_S_12   | slow slew, 12mA drive
65   LVCMOS15_F_16   LVCMOS15_F_16   | fast slew, 16mA drive
66   LVCMOS15_S_16   LVCMOS15_S_16   | slow slew, 16mA drive
|   HSTL I-IV 1.5V
67   HSTL_I   HSTL_I
68   HSTL_II   HSTL_II
69   HSTL_III   HSTL_III
70   HSTL_IV   HSTL_IV
|   HSTL I-IV 1.8V
71   HSTL_I_18   HSTL_I_18
72   HSTL_II_18   HSTL_II_18
73   HSTL_III_18   HSTL_III_18
74   HSTL_IV_18   HSTL_IV_18
|   GTL AND GTLP
75   GTL   GTL
76   GTLP   GTLP
|   SSTL2 AND SSTL18
77   SSTL2_I   SSTL2_I
78   SSTL2_II   SSTL2_II
79   SSTL18_I   SSTL18_I
80   SSTL18_II   SSTL18_II
|   PCI
81   PCI33_3   PCI33_3
82   PCI66_3   PCI66_3
83   PCIX   PCIX
|   LVDS25 GENERAL AND EXTENDED
84P   LVDS_25_P   LVDS_25
84N   LVDS_25_N   LVDS_25
85P   LVDSEXT_25_P   LVDSEXT_25
85N   LVDSEXT_25_N   LVDSEXT_25
86P   LVDS_25_DCI_P   LVDS_25_DCI
86N   LVDS_25_DCI_N   LVDS_25_DCI
|   LDT
87P   LDT_25_P   LDT_25
87N   LDT_25_N   LDT_25
|   DCI HSTL I-IV 1.5V
|   INPUT MODELS
88   HSTL_I_DCI_I   HSTL_I_DCI_I
89   HSTL_II_DCI_I   HSTL_II_DCI_I
90   HSTL_III_DCI_I   HSTL_III_DCI_I
91   HSTL_IV_DCI_I   HSTL_IV_DCI_I
|   OUTPUT MODELS
92   HSTL_I_DCI_O   HSTL_I_DCI_O
93   HSTL_II_DCI_O   HSTL_II_DCI_O
94   HSTL_III_DCI_O   HSTL_III_DCI_O
95   HSTL_IV_DCI_O   HSTL_IV_DCI_O
|   DCI HSTL I-IV 1.8V
|   INPUT MODELS
96   HSTL_I_DCI_18_I   HSTL_I_DCI_18_I
97   HSTL_II_DCI_18_I   HSTL_II_DCI_18_I
98   HSTL_III_DCI_18_I   HSTL_III_DCI_18_I
99   HSTL_IV_DCI_18_I   HSTL_IV_DCI_18_I
|   OUTPUT MODELS
100   HSTL_I_DCI_18_O   HSTL_I_DCI_18_O
101   HSTL_II_DCI_18_O   HSTL_II_DCI_18_O
102   HSTL_III_DCI_18_O   HSTL_III_DCI_18_O
103   HSTL_IV_DCI_18_O   HSTL_IV_DCI_18_O
|   DCI GTL AND GTLPLUS
|   INPUT MODELS
104   GTL_DCI_I   GTL_DCI_I
105   GTLP_DCI_I   GTLP_DCI_I
|   OUTPUT MODELS
106   GTL_DCI_O   GTL_DCI_O
107   GTLP_DCI_O   GTLP_DCI_O
|   DCI SSTL2 AND SSTL18
|   INPUT MODELS
|108   SSTL2_I_DCI_I   SSTL2_I_DCI_I   | temporarily unavailable
109   SSTL2_II_DCI_I   SSTL2_II_DCI_I
|110   SSTL18_I_DCI_I   SSTL18_I_DCI_I   | temporarily unavailable
111   SSTL18_II_DCI_I   SSTL18_II_DCI_I
|   OUTPUT MODELS
112   SSTL2_I_DCI_O   SSTL2_I_DCI_O
113   SSTL2_II_DCI_O   SSTL2_II_DCI_O
114   SSTL18_I_DCI_O   SSTL18_I_DCI_O
115   SSTL18_II_DCI_O   SSTL18_II_DCI_O
|   DCI LVCMOS15 THRU LVCMOS33 (50 ohms)
116   LVDCI_15   LVDCI_15
117   LVDCI_18   LVDCI_18
118   LVDCI_25   LVDCI_25
119   LVDCI_33   LVDCI_33
|   Differential HSTL
|   1.5V, Class II
120P   DIFF_HSTL_II_P   HSTL_II
120N   DIFF_HSTL_II_N   HSTL_II
|   1.8V, Class II
121P   DIFF_HSTL_II_18_P   HSTL_II_18
121N   DIFF_HSTL_II_18_N   HSTL_II_18
|   1.5V, Class II, DCI output
122P   DIFF_HSTL_II_DCI_O_P   HSTL_II_DCI_O
122N   DIFF_HSTL_II_DCI_O_N   HSTL_II_DCI_O
|   1.5V, Class II, DCI input
123P   DIFF_HSTL_II_DCI_I_P   HSTL_II_DCI_I
123N   DIFF_HSTL_II_DCI_I_N   HSTL_II_DCI_I
|   1.8V, Class II, DCI output
124P   DIFF_HSTL2_DCI_18_OP   HSTL_II_DCI_18_O
124N   DIFF_HSTL2_DCI_18_ON   HSTL_II_DCI_18_O
|   1.8V, Class II, DCI input
125P   DIFF_HSTL2_DCI_18_IP   HSTL_II_DCI_18_I
125N   DIFF_HSTL2_DCI_18_IN   HSTL_II_DCI_18_I
|   Differential SSTL
|   2.5V Class II
126P   DIFF_SSTL2_II_P   SSTL2_II
126N   DIFF_SSTL2_II_N   SSTL2_II
|   1.8V Class II
127P   DIFF_SSTL_II_18_P   SSTL18_II
127N   DIFF_SSTL_II_18_N   SSTL18_II
|   2.5V Class II, DCI output
128P   DIFF_SSTL2_II_DCI_OP   SSTL2_II_DCI_O
128N   DIFF_SSTL2_II_DCI_ON   SSTL2_II_DCI_O
|   2.5V Class II, DCI input
129P   DIFF_SSTL2_II_DCI_IP   SSTL2_II_DCI_I
129N   DIFF_SSTL2_II_DCI_IN   SSTL2_II_DCI_I
|   1.8V Class II, DCI output
130P   DIFF_SSTL18II_DCI_OP   SSTL18_II_DCI_O
130N   DIFF_SSTL18II_DCI_ON   SSTL18_II_DCI_O
|   1.8V Class II, DCI input
131P   DIFF_SSTL18II_DCI_IP   SSTL18_II_DCI_I
131N   DIFF_SSTL18II_DCI_IN   SSTL18_II_DCI_I
132   LVDCI_15_DV2   LVDCI_15
133   LVDCI_18_DV2   LVDCI_18
134   LVDCI_25_DV2   LVDCI_25
135   LVDCI_33_DV2   LVDCI_33
PGND   GND   GND
VCCO   VCCO   POWER
[Diff Pin]   inv_pin   vdiff   tdelay_typ   tdelay_min   tdelay_max
84P   84N   100mV   0   0   0
85P   85N   100mV   0   0   0
86P   86N   100mV   0   0   0
87P   87N   200mV   0   0   0
120P   120N   200mV   0   0   0
121P   121N   200mV   0   0   0
122P   122N   200mV   0   0   0
123P   123N   200mV   0   0   0
124P   124N   200mV   0   0   0
125P   125N   200mV   0   0   0
126P   126N   300mV   0   0   0
127P   127N   250mV   0   0   0
128P   128N   300mV   0   0   0
129P   129N   300mV   0   0   0
130P   130N   250mV   0   0   0
131P   131N   250mV   0   0   0
| Models and submodels in the file (117): LVTTL_F_2 (I/O), LVTTL_F_4 (I/O), LVTTL_F_6 (I/O), LVTTL_F_8 (I/O), LVTTL_F_12 (I/O), LVTTL_F_16 (I/O), LVTTL_F_24 (I/O), LVTTL_S_2 (I/O), LVTTL_S_4 (I/O), LVTTL_S_6 (I/O), LVTTL_S_8 (I/O), LVTTL_S_12 (I/O), LVTTL_S_16 (I/O), LVTTL_S_24 (I/O), LVCMOS33_F_2 (I/O), LVCMOS33_F_4 (I/O), LVCMOS33_F_6 (I/O), LVCMOS33_F_8 (I/O), LVCMOS33_F_12 (I/O), LVCMOS33_F_16 (I/O), LVCMOS33_F_24 (I/O), LVCMOS33_S_2 (I/O), LVCMOS33_S_4 (I/O), LVCMOS33_S_6 (I/O), LVCMOS33_S_8 (I/O), LVCMOS33_S_12 (I/O), LVCMOS33_S_16 (I/O), LVCMOS33_S_24 (I/O), LVCMOS25_F_2 (I/O), LVCMOS25_F_4 (I/O), LVCMOS25_F_6 (I/O), LVCMOS25_F_8 (I/O), LVCMOS25_F_12 (I/O), LVCMOS25_F_16 (I/O), LVCMOS25_F_24 (I/O), LVCMOS25_S_2 (I/O), LVCMOS25_S_4 (I/O), LVCMOS25_S_6 (I/O), LVCMOS25_S_8 (I/O), LVCMOS25_S_12 (I/O), LVCMOS25_S_16 (I/O), LVCMOS25_S_24 (I/O), LVCMOS18_F_2 (I/O), LVCMOS18_F_4 (I/O), LVCMOS18_F_6 (I/O), LVCMOS18_F_8 (I/O), LVCMOS18_F_12 (I/O), LVCMOS18_F_16 (I/O), LVCMOS18_S_2 (I/O), LVCMOS18_S_4 (I/O), LVCMOS18_S_6 (I/O), LVCMOS18_S_8 (I/O), LVCMOS18_S_12 (I/O), LVCMOS18_S_16 (I/O), LVCMOS15_F_2 (I/O), LVCMOS15_F_4 (I/O), LVCMOS15_F_6 (I/O), LVCMOS15_F_8 (I/O), LVCMOS15_F_12 (I/O), LVCMOS15_F_16 (I/O), LVCMOS15_S_2 (I/O), LVCMOS15_S_4 (I/O), LVCMOS15_S_6 (I/O), LVCMOS15_S_8 (I/O), LVCMOS15_S_12 (I/O), LVCMOS15_S_16 (I/O), HSTL_I (I/O), HSTL_II (I/O), HSTL_III (I/O), HSTL_IV (I/O), HSTL_I_18 (I/O), HSTL_II_18 (I/O), HSTL_III_18 (I/O), HSTL_IV_18 (I/O), GTL (I/O_open_drain), GTLP (I/O_open_drain), SSTL2_I (I/O), SSTL2_II (I/O), SSTL18_I (I/O), SSTL18_II (I/O)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
