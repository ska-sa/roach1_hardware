| u27a.ibs * IBIS 3.2 Model
| 512Mb DDR-2 SDRAM
|  Part Number   VDD/VDDQ   Architecture   Package
| MT47H128M4FT   1.8V/1.8V   128Meg x 4   92-Ball FBGA
| MT47H64M8FT   1.8V/1.8V   64Meg x 8   92-Ball FBGA
| MT47H32M16FT   1.8V/1.8V   32Meg x 16   92-Ball FBGA
[IBIS Ver]   3.2
[File name]   u27a.ibs
[Date]   11/24/2003
[File Rev]   2.0
[Source]   From silicon level SPICE model at Micron Technology, Inc.
   Micron Technology, Inc.
   8000 S. Federal Way
   P.O. Box 6, M/S: 01-711
   Boise, ID 83707-0006
[Notes]   Rev 2.0: 11/24/2003
   - all models match latest silicon measurements
[Disclaimer]  This software code and all associated documentation, comments
              or other information (collectively "Software") is provided
              "AS IS" without warranty of any kind. MICRON TECHNOLOGY, INC.
              ("MTI") EXPRESSLY DISCLAIMS ALL WARRANTIES EXPRESS OR IMPLIED,
              INCLUDING BUT NOT LIMITED TO, NONINFRINGEMENT OF THIRD PARTY
              RIGHTS, AND ANY IMPLIED WARRANTIES OF MERCHANTABILITY OR
              FITNESS FOR ANY PARTICULAR PURPOSE. MTI DOES NOT WARRANT THAT
              THE SOFTWARE WILL MEET YOUR REQUIREMENTS, OR THAT THE
              OPERATION OF THE SOFTWARE WILL BE UNINTERRUPTED OR ERROR-FREE.
              FURTHERMORE, MTI DOES NOT MAKE ANY REPRESENTATIONS REGARDING
              THE USE OR THE RESULTS OF THE USE OF THE SOFTWARE IN TERMS OF
              ITS CORRECTNESS, ACCURACY, RELIABILITY, OR OTHERWISE. THE
              ENTIRE RISK ARISING OUT OF USE OR PERFORMANCE OF THE SOFTWARE
              REMAINS WITH YOU. IN NO EVENT SHALL MTI, ITS AFFILIATED
              COMPANIES OR THEIR SUPPLIERS BE LIABLE FOR ANY DIRECT,
              INDIRECT, CONSEQUENTIAL, INCIDENTAL, OR SPECIAL DAMAGES
              (INCLUDING, WITHOUT LIMITATION, DAMAGES FOR LOSS OF PROFITS,
              BUSINESS INTERRUPTION, OR LOSS OF INFORMATION) ARISING OUT OF
              YOUR USE OF OR INABILITY TO USE THE SOFTWARE, EVEN IF MTI HAS
              BEEN ADVISED OF THE POSSIBILITY OF SUCH DAMAGES. Because some
              jurisdictions prohibit the exclusion or limitation of
              liability for consequential or incidental damages, the above
              limitation may not apply to you.
[Copyright]   Copyright 2003 Micron Technology, Inc. All rights reserved.
|   COMPONENT: MT47H128M4FT
[Component]   MT47H128M4FT
[Manufacturer]  Micron Technology, Inc.
[Package]   | 11mm x 19mm FBGA
|variable   typ   min   max
R_pkg   73.8m   52.5m   99.4m
L_pkg   2.19nH   1.43nH   3.63nH
C_pkg   0.29pF   0.21pF   0.39pF
[Pin]  signal_name   model_name   R_pin   L_pin   C_pin
A1   NC   NC   NA   NA   NA
A2   NC   NC   NA   NA   NA
A8   NC   NC   NA   NA   NA
A9   NC   NC   NA   NA   NA
D1   VDD   POWER   40.7m   0.94nH   2.13pF
D2   NC   NC   NA   NA   NA
D3   VSS   GND   26.0m   0.88nH   2.67pF
D7   VSSQ   GND   51.0m   1.36nH   0.22pF
D8   NC   NC   NA   NA   NA
D9   VDDQ   POWER   28.4m   1.27nH   0.42pF
E1   NC   NC   NA   NA   NA
E2   NC   NC   NA   NA   NA
E3   NC   NC   NA   NA   NA
E7   NC   NC   NA   NA   NA
E8   NC   NC   NA   NA   NA
E9   NC   NC   NA   NA   NA
F1   NC   NC   NA   NA   NA
F2   NC   NC   NA   NA   NA
F3   NC   NC   NA   NA   NA
F7   NC   NC   NA   NA   NA
F8   NC   NC   NA   NA   NA
F9   NC   NC   NA   NA   NA
G1   NC   NC   NA   NA   NA
G2   NC   NC   NA   NA   NA
G3   NC   NC   NA   NA   NA
G7   NC   NC   NA   NA   NA
G8   NC   NC   NA   NA   NA
G9   NC   NC   NA   NA   NA
H1   VDD   POWER   40.7m   0.94nH   2.13pF
H2   NC   NC   NA   NA   NA
H3   VSS   GND   25.8m   1.00nH   0.27pF
H7   VSSQ   GND   52.5m   1.49nH   0.23pF
H8   DQS#/NU   DQS#   86.7m   2.75nH   0.35pF
H9   VDDQ   POWER   28.4m   1.27nH   0.42pF
J1   NF   NF_INPUT   88.9m   3.07nH   0.37pF
J2   VSSQ   GND   67.9m   2.19nH   0.29pF
J3   DM   DM_INPUT   83.2m   2.08nH   0.28pF
J7   DQS   DQ   83.8m   2.06nH   0.28pF
J8   VSSQ   GND   67.7m   2.18nH   0.30pF
J9   NF   NF_INPUT   91.1m   3.17nH   0.38pF
K1   VDDQ   POWER   42.3m   1.89nH   0.31pF
K2   DQ1   DQ   87.9m   2.70nH   0.35pF
K3   VDDQ   POWER   34.7m   1.12nH   0.31pF
K7   VDDQ   POWER   28.4m   1.27nH   0.42pF
K8   DQ0   DQ   86.9m   2.78nH   0.36pF
K9   VDDQ   POWER   28.4m   1.27nH   0.42pF
L1   NF   NF_INPUT   98.7m   2.62nH   0.36pF
L2   VSSQ   GND   71.4m   2.07nH   0.29pF
L3   DQ3   DQ   83.6m   1.85nH   0.27pF
L7   DQ2   DQ   78.1m   1.90nH   0.25pF
L8   VSSQ   GND   65.7m   2.17nH   0.28pF
L9   NF   NF_INPUT   88.9m   3.08nH   0.36pF
M1   VDDL   POWER   96.2m   2.55nH   0.35pF
M2   VREF   POWER   78.9m   1.89nH   0.30pF
M3   VSS   GND   26.0m   0.88nH   2.67pF
M7   VSSDL   GND   52.0m   1.44nH   0.21pF
M8   CK   CLKIN   72.8m   2.32nH   0.30pF
M9   VDD   POWER   23.0m   0.83nH   3.41pF
N2   CKE   INPUT   74.9m   2.20nH   0.30pF
N3   WE#   INPUT   56.0m   1.44nH   0.22pF
N7   RAS#   INPUT   56.5m   1.56nH   0.23pF
N8   CK#   CLKIN   72.1m   2.28nH   0.29pF
N9   ODT   INPUT   99.4m   3.63nH   0.39pF
P1   RFU   NC   NA   NA   NA
P2   BA0   INPUT   72.7m   2.12nH   0.30pF
P3   BA1   INPUT   57.4m   1.46nH   0.23pF
P7   CAS#   INPUT   52.5m   1.43nH   0.21pF
P8   CS#   INPUT   67.3m   2.22nH   0.27pF
R2   A10   INPUT   80.8m   2.27nH   0.33pF
R3   A1   INPUT   64.4m   1.48nH   0.26pF
R7   A2   INPUT   58.7m   1.66nH   0.24pF
R8   A0   INPUT   74.1m   2.44nH   0.29pF
R9   VDD   POWER   23.0m   0.83nH   3.41pF
S1   VSS   GND   26.0m   0.88nH   2.67pF
S2   A3   INPUT   75.6m   2.28nH   0.30pF
S3   A5   INPUT   57.4m   1.50nH   0.24pF
S7   A6   INPUT   53.4m   1.54nH   0.21pF
S8   A4   INPUT   71.9m   2.39nH   0.26pF
T2   A7   INPUT   71.7m   2.21nH   0.29pF
T3   A9   INPUT   57.8m   1.56nH   0.24pF
T7   A11   INPUT   53.1m   1.45nH   0.22pF
T8   A8   INPUT   73.1m   2.24nH   0.29pF
T9   VSS   GND   17.4m   0.74nH   7.81pF
U1   VDD   POWER   40.7m   0.94nH   2.13pF
U2   A12   INPUT   68.0m   2.15nH   0.27pF
U3   RFU   NC   NA   NA   NA
U7   RFU   NC   NA   NA   NA
U8   A13   INPUT   70.1m   2.14nH   0.28pF
X1   NC   NC   NA   NA   NA
X2   NC   NC   NA   NA   NA
X8   NC   NC   NA   NA   NA
X9   NC   NC   NA   NA   NA
Y1   NC   NC   NA   NA   NA
Y2   NC   NC   NA   NA   NA
Y8   NC   NC   NA   NA   NA
Y9   NC   NC   NA   NA   NA
|**********************DIFF PIN*********************************************
[Diff_pin]   inv_pin   vdiff   tdelay_typ   tdelay_min   tdelay_max
   M8   N8   .250V   0ns   NA   NA
   J7   H8   .250V   0ns   NA   NA
|  Pins J7 and H8 are a differential I/O only when DQS# is enabled via MRS
|  If DQS# is disabled, then J7 (DQS) is a single ended I/O and H8 is a NC
|   COMPONENT: MT47H64M8FT
[Component]   MT47H64M8FT
[Manufacturer]  Micron Technology, Inc.
[Package]   | 11mm x 19mm FBGA
|variable   typ   min   max
R_pkg   73.8m   52.5m   99.4m
L_pkg   2.19nH   1.43nH   3.63nH
C_pkg   0.29pF   0.21pF   0.39pF
[Pin]  signal_name   model_name   R_pin   L_pin   C_pin
A1   NC   NC   NA   NA   NA
A2   NC   NC   NA   NA   NA
A8   NC   NC   NA   NA   NA
A9   NC   NC   NA   NA   NA
D1   VDD   POWER   40.7m   0.94nH   2.13pF
D2   NC   NC   NA   NA   NA
D3   VSS   GND   26.0m   0.88nH   2.67pF
D7   VSSQ   GND   51.0m   1.36nH   0.22pF
D8   NC   NC   NA   NA   NA
D9   VDDQ   POWER   28.4m   1.27nH   0.42pF
E1   NC   NC   NA   NA   NA
E2   NC   NC   NA   NA   NA
E3   NC   NC   NA   NA   NA
E7   NC   NC   NA   NA   NA
E8   NC   NC   NA   NA   NA
E9   NC   NC   NA   NA   NA
F1   NC   NC   NA   NA   NA
F2   NC   NC   NA   NA   NA
F3   NC   NC   NA   NA   NA
F7   NC   NC   NA   NA   NA
F8   NC   NC   NA   NA   NA
F9   NC   NC   NA   NA   NA
G1   NC   NC   NA   NA   NA
G2   NC   NC   NA   NA   NA
G3   NC   NC   NA   NA   NA
G7   NC   NC   NA   NA   NA
G8   NC   NC   NA   NA   NA
G9   NC   NC   NA   NA   NA
H1   VDD   POWER   40.7m   0.94nH   2.13pF
H2   RDQS#/NU   RDQS#   87.0m   2.74nH   0.34pF
H3   VSS   GND   25.8m   1.00nH   0.27pF
H7   VSSQ   GND   52.5m   1.49nH   0.23pF
H8   DQS#/NU   DQS#   86.7m   2.75nH   0.35pF
H9   VDDQ   POWER   28.4m   1.27nH   0.42pF
J1   DQ6   DQ   88.9m   3.07nH   0.37pF
J2   VSSQ   GND   67.9m   2.19nH   0.29pF
J3   DM/RDQS   DM_RDQS   83.2m   2.08nH   0.28pF
J7   DQS   DQ   83.8m   2.06nH   0.28pF
J8   VSSQ   GND   67.7m   2.18nH   0.30pF
J9   DQ7   DQ   91.1m   3.17nH   0.38pF
K1   VDDQ   POWER   42.3m   1.89nH   0.31pF
K2   DQ1   DQ   87.9m   2.70nH   0.35pF
K3   VDDQ   POWER   34.7m   1.12nH   0.31pF
K7   VDDQ   POWER   28.4m   1.27nH   0.42pF
K8   DQ0   DQ   86.9m   2.78nH   0.36pF
K9   VDDQ   POWER   28.4m   1.27nH   0.42pF
L1   DQ4   DQ   98.7m   2.62nH   0.36pF
L2   VSSQ   GND   71.4m   2.07nH   0.29pF
L3   DQ3   DQ   83.6m   1.85nH   0.27pF
L7   DQ2   DQ   78.1m   1.90nH   0.25pF
L8   VSSQ   GND   65.7m   2.17nH   0.28pF
L9   DQ5   DQ   88.9m   3.08nH   0.36pF
M1   VDDL   POWER   96.2m   2.55nH   0.35pF
M2   VREF   POWER   78.9m   1.89nH   0.30pF
M3   VSS   GND   26.0m   0.88nH   2.67pF
M7   VSSDL   GND   52.0m   1.44nH   0.21pF
M8   CK   CLKIN   72.8m   2.32nH   0.30pF
M9   VDD   POWER   23.0m   0.83nH   3.41pF
N2   CKE   INPUT   74.9m   2.20nH   0.30pF
N3   WE#   INPUT   56.0m   1.44nH   0.22pF
N7   RAS#   INPUT   56.5m   1.56nH   0.23pF
N8   CK#   CLKIN   72.1m   2.28nH   0.29pF
N9   ODT   INPUT   99.4m   3.63nH   0.39pF
P1   RFU   NC   NA   NA   NA
P2   BA0   INPUT   72.7m   2.12nH   0.30pF
P3   BA1   INPUT   57.4m   1.46nH   0.23pF
P7   CAS#   INPUT   52.5m   1.43nH   0.21pF
P8   CS#   INPUT   67.3m   2.22nH   0.27pF
R2   A10   INPUT   80.8m   2.27nH   0.33pF
R3   A1   INPUT   64.4m   1.48nH   0.26pF
R7   A2   INPUT   58.7m   1.66nH   0.24pF
R8   A0   INPUT   74.1m   2.44nH   0.29pF
R9   VDD   POWER   23.0m   0.83nH   3.41pF
S1   VSS   GND   26.0m   0.88nH   2.67pF
S2   A3   INPUT   75.6m   2.28nH   0.30pF
S3   A5   INPUT   57.4m   1.50nH   0.24pF
S7   A6   INPUT   53.4m   1.54nH   0.21pF
S8   A4   INPUT   71.9m   2.39nH   0.26pF
T2   A7   INPUT   71.7m   2.21nH   0.29pF
T3   A9   INPUT   57.8m   1.56nH   0.24pF
T7   A11   INPUT   53.1m   1.45nH   0.22pF
T8   A8   INPUT   73.1m   2.24nH   0.29pF
T9   VSS   GND   17.4m   0.74nH   7.81pF
U1   VDD   POWER   40.7m   0.94nH   2.13pF
U2   A12   INPUT   68.0m   2.15nH   0.27pF
U3   RFU   NC   NA   NA   NA
U7   RFU   NC   NA   NA   NA
U8   A13   INPUT   70.1m   2.14nH   0.28pF
X1   NC   NC   NA   NA   NA
X2   NC   NC   NA   NA   NA
X8   NC   NC   NA   NA   NA
X9   NC   NC   NA   NA   NA
Y1   NC   NC   NA   NA   NA
Y2   NC   NC   NA   NA   NA
Y8   NC   NC   NA   NA   NA
Y9   NC   NC   NA   NA   NA
|**********************DIFF PIN*********************************************
[Diff_pin]   inv_pin   vdiff   tdelay_typ   tdelay_min   tdelay_max
   M8   N8   .250V   0ns   NA   NA
   J7   H8   .250V   0ns   NA   NA
|  Pins J7 and H8 are a differential I/O only when DQS# is enabled via MRS
|  If DQS# is disabled, then J7 (DQS) is a single ended I/O and H8 is a NC
|   J3   H2   .250V   0ns   NA   NA
|  Pins J3 and H2 (RDQS,RDQS#) are a differential output only if RDQS and
|  Differential Stobe MRS options are enabled
|   Model Selector
[Model Selector] RDQS#
NC   Not Used if either RDQS or Diff. Strobe are disabled
RDQS   Full-Strength Output Driver
[Model Selector] DM_RDQS
DM_INPUT   DM input model
RDQS   Full-Strength Output Driver if RDQS is enabled
|   COMPONENT: MT47H32M16FT
[Component]   MT47H32M16FT
[Manufacturer]  Micron Technology, Inc.
[Package]   | 11mm x 19mm FBGA
|variable   typ   min   max
R_pkg   77.2m   52.5m   99.4m
L_pkg   2.29nH   1.43nH   3.63nH
C_pkg   0.30pF   0.21pF   0.39pF
[Pin]  signal_name   model_name   R_pin   L_pin   C_pin
A1   NC   NC   NA   NA   NA
A2   NC   NC   NA   NA   NA
A8   NC   NC   NA   NA   NA
A9   NC   NC   NA   NA   NA
D1   VDD   POWER   40.7m   0.94nH   2.13pF
D2   NC   NC   NA   NA   NA
D3   VSS   GND   26.0m   0.88nH   2.67pF
D7   VSSQ   GND   51.0m   1.36nH   0.22pF
D8   UDQS#/NU   DQS#   88.5m   2.53nH   0.36pF
D9   VDDQ   POWER   28.4m   1.27nH   0.42pF
E1   DQ14   DQ   98.1m   3.02nH   0.38pF
E2   VSSQ   GND   77.7m   2.31nH   0.31pF
E3   UDM   DM_INPUT   85.0m   2.31nH   0.29pF
E7   UDQS   DQ   82.9m   2.05nH   0.26pF
E8   VSSQ   GND   67.0m   2.16nH   0.29pF
E9   DQ15   DQ   93.5m   3.21nH   0.38pF
F1   VDDQ   POWER   48.9m   2.06nH   0.40pF
F2   DQ9   DQ   87.7m   2.81nH   0.33pF
F3   VDDQ   POWER   38.9m   1.21nH   0.40pF
F7   VDDQ   POWER   28.4m   1.27nH   0.42pF
F8   DQ8   DQ   87.7m   2.82nH   0.33pF
F9   VDDQ   POWER   28.4m   1.27nH   0.42pF
G1   DQ12   DQ   91.1m   3.18nH   0.38pF
G2   VSSQ   GND   75.0m   2.38nH   0.31pF
G3   DQ11   DQ   83.1m   1.94nH   0.27pF
G7   DQ10   DQ   85.9m   2.27nH   0.31pF
G8   VSSQ   GND   67.1m   2.15nH   0.29pF
G9   DQ13   DQ   89.7m   3.10nH   0.37pF
H1   VDD   POWER   40.7m   0.94nH   2.13pF
H2   NC   NC   NA   NA   NA
H3   VSS   GND   25.8m   1.00nH   0.27pF
H7   VSSQ   GND   52.5m   1.49nH   0.23pF
H8   LDQS#/NU   DQS#   86.7m   2.75nH   0.35pF
H9   VDDQ   POWER   28.4m   1.27nH   0.42pF
J1   DQ6   DQ   88.9m   3.07nH   0.37pF
J2   VSSQ   GND   67.9m   2.19nH   0.29pF
J3   LDM   DM_INPUT   83.2m   2.08nH   0.28pF
J7   LDQS   DQ   83.8m   2.06nH   0.28pF
J8   VSSQ   GND   67.7m   2.18nH   0.30pF
J9   DQ7   DQ   91.1m   3.17nH   0.38pF
K1   VDDQ   POWER   42.3m   1.89nH   0.31pF
K2   DQ1   DQ   87.9m   2.70nH   0.35pF
K3   VDDQ   POWER   34.7m   1.12nH   0.31pF
K7   VDDQ   POWER   28.4m   1.27nH   0.42pF
K8   DQ0   DQ   86.9m   2.78nH   0.36pF
K9   VDDQ   POWER   28.4m   1.27nH   0.42pF
L1   DQ4   DQ   98.7m   2.62nH   0.36pF
L2   VSSQ   GND   71.4m   2.07nH   0.29pF
L3   DQ3   DQ   83.6m   1.85nH   0.27pF
L7   DQ2   DQ   78.1m   1.90nH   0.25pF
L8   VSSQ   GND   65.7m   2.17nH   0.28pF
L9   DQ5   DQ   88.9m   3.08nH   0.36pF
M1   VDDL   POWER   96.2m   2.55nH   0.35pF
M2   VREF   POWER   78.9m   1.89nH   0.30pF
M3   VSS   GND   26.0m   0.88nH   2.67pF
M7   VSSDL   GND   52.0m   1.44nH   0.21pF
M8   CK   CLKIN   72.8m   2.32nH   0.30pF
M9   VDD   POWER   23.0m   0.83nH   3.41pF
N2   CKE   INPUT   74.9m   2.20nH   0.30pF
N3   WE#   INPUT   56.0m   1.44nH   0.22pF
N7   RAS#   INPUT   56.5m   1.56nH   0.23pF
N8   CK#   CLKIN   72.1m   2.28nH   0.29pF
N9   ODT   INPUT   99.4m   3.63nH   0.39pF
P1   RFU   NC   NA   NA   NA
P2   BA0   INPUT   72.7m   2.12nH   0.30pF
P3   BA1   INPUT   57.4m   1.46nH   0.23pF
P7   CAS#   INPUT   52.5m   1.43nH   0.21pF
P8   CS#   INPUT   67.3m   2.22nH   0.27pF
R2   A10   INPUT   80.8m   2.27nH   0.33pF
R3   A1   INPUT   64.4m   1.48nH   0.26pF
R7   A2   INPUT   58.7m   1.66nH   0.24pF
R8   A0   INPUT   74.1m   2.44nH   0.29pF
R9   VDD   POWER   23.0m   0.83nH   3.41pF
T1   VSS   GND   26.0m   0.88nH   2.67pF
T2   A3   INPUT   75.6m   2.28nH   0.30pF
T3   A5   INPUT   57.4m   1.50nH   0.24pF
T7   A6   INPUT   53.4m   1.54nH   0.21pF
T8   A4   INPUT   71.9m   2.39nH   0.26pF
U2   A7   INPUT   71.7m   2.21nH   0.29pF
U3   A9   INPUT   57.8m   1.56nH   0.24pF
U7   A11   INPUT   53.1m   1.45nH   0.22pF
U8   A8   INPUT   73.1m   2.24nH   0.29pF
U9   VSS   GND   17.4m   0.74nH   7.81pF
V1   VDD   POWER   40.7m   0.94nH   2.13pF
V2   A12   INPUT   68.0m   2.15nH   0.27pF
V3   RFU   NC   NA   NA   NA
V7   RFU   NC   NA   NA   NA
V8   NC   NC   NA   NA   NA
AA1   NC   NC   NA   NA   NA
AA2   NC   NC   NA   NA   NA
AA8   NC   NC   NA   NA   NA
AA9   NC   NC   NA   NA   NA
|**********************DIFF PIN*********************************************
[Diff_pin]   inv_pin   vdiff   tdelay_typ   tdelay_min   tdelay_max
   M8   N8   .250V   0ns   NA   NA
   E7   D8   .250V   0ns   NA   NA
|  Pins E7 and D8 are a differential I/O only when DQS# is enabled via MRS
|  If DQS# is disabled, then E7(UDQS) is a single ended I/O and D8 is a NC
   J7   H8   .250V   0ns   NA   NA
|  Pins J7 and H8 are a differential I/O only when DQS# is enabled via MRS
|  If DQS# is disabled, then J7(LDQS) is a single ended I/O and H8 is a NC
|   Model Selector
[Model Selector] DQS#
DQ   Full-Strength IO Driver
NC   (Use to disable DQS#)
| Models and submodels in the file (6): DQ (I/O), RDQS (3-state), INPUT (Input), DM_INPUT (Input), CLKIN (Input), NF_INPUT (Terminator)
