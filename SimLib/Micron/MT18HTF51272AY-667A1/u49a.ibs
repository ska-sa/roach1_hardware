| u49a.ibs * IBIS 4.0 Model
| 2Gb DDR-2 SDRAM - Die Revision "A"
| Valid for DDR2-400/533/667/800 operation
| Models *_533 are applicable for speed grade 400/533 Mbps
| Models *_800 are applicable for speed grade 667/800 Mbps
|  Part Number   VDD/VDDQ   Architecture   Package
| MT47H512M4HG   1.8V/1.8V   512Meg x 4   60-Ball FBGA
| MT47H512M4HG_CLP   1.8V/1.8V   512Meg x 4   Common Landing Pattern
| MT47H256M8HG   1.8V/1.8V   256Meg x 8   60-Ball FBGA
| MT47H256M8HG_CLP   1.8V/1.8V   256Meg x 8   Common Landing Pattern
| MT47H128M16HG   1.8V/1.8V   128Meg x 16   84-Ball FBGA
| MT47H128M16HG_CLP   1.8V/1.8V   128Meg x 16   Common Landing Pattern
[IBIS Ver]   4.0
[File name]   u49a.ibs
[Date]   06/04/2007
[File Rev]   2.1
[Source]   From silicon level SPICE model at Micron Technology, Inc.
   Micron Technology, Inc.
   8000 S. Federal Way
   P.O. Box 6, M/S: 01-711
   Boise, ID 83707-0006
   For support e-mail modelsupport@micron.com
[Notes]   Revision History:
   Rev 2.0: 09/07/2006
   - Revision matched to silicon measurements
   - All ODT models included within one IBIS file
   - ODT modeled with [Submodel]
   Rev 2.1: 06/04/2007
   - File includes models for 400,533,667 and 800 speed grades
   - Updated C_comp for all models
   - Updated Vinl, vinh, vinl_ac and vinh_ac parameters for 800 speed grade
   - Pins K9 and U9 correctly set to GND
|IQ SUMMARY Overall Quality of component and models Level 2b
|See Micron IBIS Model Quality Report for full IQ SUMMARY
[Disclaimer]  This software code and all associated documentation, comments
              or other information (collectively "Software") is provided
              "AS IS" without warranty of any kind. MICRON TECHNOLOGY, INC.
              ("MTI") EXPRESSLY DISCLAIMS ALL WARRANTIES EXPRESS OR IMPLIED,
              INCLUDING BUT NOT LIMITED TO, NONINFRINGEMENT OF THIRD PARTY
              RIGHTS, AND ANY IMPLIED WARRANTIES OF MERCHANTABILITY OR
              FITNESS FOR ANY PARTICULAR PURPOSE. MTI DOES NOT WARRANT THAT
              THE SOFTWARE WILL MEET YOUR REQUIREMENTS, OR THAT THE
              OPERATION OF THE SOFTWARE WILL BE UNINTERRUPTED OR ERROR-FREE.
              FURTHERMORE, MTI DOES NOT MAKE ANY REPRESENTATIONS REGARDING
              THE USE OR THE RESULTS OF THE USE OF THE SOFTWARE IN TERMS OF
              ITS CORRECTNESS, ACCURACY, RELIABILITY, OR OTHERWISE. THE
              ENTIRE RISK ARISING OUT OF USE OR PERFORMANCE OF THE SOFTWARE
              REMAINS WITH YOU. IN NO EVENT SHALL MTI, ITS AFFILIATED
              COMPANIES OR THEIR SUPPLIERS BE LIABLE FOR ANY DIRECT,
              INDIRECT, CONSEQUENTIAL, INCIDENTAL, OR SPECIAL DAMAGES
              (INCLUDING, WITHOUT LIMITATION, DAMAGES FOR LOSS OF PROFITS,
              BUSINESS INTERRUPTION, OR LOSS OF INFORMATION) ARISING OUT OF
              YOUR USE OF OR INABILITY TO USE THE SOFTWARE, EVEN IF MTI HAS
              BEEN ADVISED OF THE POSSIBILITY OF SUCH DAMAGES. Because some
              jurisdictions prohibit the exclusion or limitation of
              liability for consequential or incidental damages, the above
              limitation may not apply to you.
[Copyright]   Copyright 2006 Micron Technology, Inc. All rights reserved.
|   COMPONENT: MT47H512M4HG
[Component]   MT47H512M4HG
[Manufacturer]  Micron Technology, Inc.
[Package]   | 11.5mm x 14mm FBGA
|variable   typ   min   max
R_pkg   54.8m   21.2m   88.4m
L_pkg   1.45nH   0.81nH   2.43nH
C_pkg   0.14pF   0.11pF   0.19pF
[Pin]  signal_name   model_name   R_pin   L_pin   C_pin
A1   VDD   POWER   70.6m   1.62nH   0.35pF
A2   NF   NF_INPUT   42.9m   1.54nH   0.15pF
A3   VSS   GND   24.2m   1.04nH   NA
A7   VSSQ   GND   54.0m   0.87nH   NA
A8   DQS#   DQS#   46.5m   1.67nH   0.17pF
A9   VDDQ   POWER   56.2m   1.09nH   0.14pF
B1   NF   NF_INPUT   59.1m   2.43nH   0.19pF
B2   VSSQ   GND   54.0m   0.87nH   NA
B3   DM   DM   26.0m   0.87nH   0.12pF
B7   DQS   DQ   24.5m   0.89nH   0.12pF
B8   VSSQ   GND   54.0m   0.87nH   NA
B9   NF   NF_INPUT   66.1m   2.15nH   0.18pF
C1   VDDQ   POWER   56.2m   1.09nH   0.14pF
C2   DQ1   DQ   37.4m   1.46nH   0.14pF
C3   VDDQ   POWER   56.2m   1.09nH   0.14pF
C7   VDDQ   POWER   56.2m   1.09nH   0.14pF
C8   DQ0   DQ   39.3m   2.06nH   0.15pF
C9   VDDQ   POWER   56.2m   1.09nH   0.14pF
D1   NF   NF_INPUT   48.1m   1.92nH   0.16pF
D2   VSSQ   GND   54.0m   0.87nH   NA
D3   DQ3   DQ   25.5m   0.90nH   0.11pF
D7   DQ2   DQ   29.2m   0.88nH   0.12pF
D8   VSSQ   GND   54.0m   0.87nH   NA
D9   NF   NF_INPUT   53.9m   2.02nH   0.18pF
E1   VDDL   POWER   52.2m   2.06nH   0.17pF
E2   VREF   POWER   37.6m   1.47nH   0.14pF
E3   VSS   GND   24.2m   1.04nH   NA
E7   VSSDL   GND   29.5m   1.11nH   NA
E8   CK   CLK   41.6m   1.62nH   0.16pF
E9   VDD   POWER   70.6m   1.62nH   0.35pF
F1   NC   NC
F2   CKE0   INPUT   42.1m   1.53nH   0.15pF
F3   WE#   INPUT   88.4m   1.12nH   0.12pF
F7   RAS#   INPUT   29.5m   1.11nH   0.13pF
F8   CK#   CLK   44.7m   1.73nH   0.16pF
F9   ODT0   INPUT   58.7m   2.33nH   0.19pF
G1   BA2   INPUT   57.5m   2.14nH   0.18pF
G2   BA0   INPUT   39.0m   1.45nH   0.15pF
G3   BA1   INPUT   24.2m   0.89nH   0.12pF
G7   CAS#   INPUT   22.4m   0.84nH   0.11pF
G8   CS0#   INPUT   48.1m   1.53nH   0.15pF
G9   NC   NC
H1   NC   NC
H2   A10   INPUT   40.3m   1.47nH   0.14pF
H3   A1   INPUT   24.3m   0.92nH   0.12pF
H7   A2   INPUT   28.6m   0.93nH   0.12pF
H8   A0   INPUT   37.0m   1.43nH   0.15pF
H9   VDD   POWER   70.6m   1.62nH   0.35pF
J1   VSS   GND   24.2m   1.04nH   NA
J2   A3   INPUT   42.3m   1.60nH   0.15pF
J3   A5   INPUT   27.7m   1.05nH   0.12pF
J7   A6   INPUT   31.8m   1.16nH   0.13pF
J8   A4   INPUT   43.1m   1.64nH   0.16pF
J9   NC   NC
K1   NC   NC
K2   A7   INPUT   41.6m   1.58nH   0.15pF
K3   A9   INPUT   26.0m   0.99nH   0.12pF
K7   A11   INPUT   45.5m   1.63nH   0.15pF
K8   A8   INPUT   64.6m   1.99nH   0.17pF
K9   VSS   GND   24.2m   1.04nH   NA
L1   VDD   POWER   70.6m   1.62nH   0.35pF
L2   A12   INPUT   38.1m   1.45nH   0.15pF
L3   A14   INPUT   21.2m   0.81nH   0.11pF
L7   NC   NC
L8   A13   INPUT   39.8m   1.40nH   0.14pF
|**********************DIFF PIN*********************************************
[Diff_pin]   inv_pin   vdiff   tdelay_typ   tdelay_min   tdelay_max
   E8   F8   .250V   0ns   NA   NA
   B7   A8   .250V   0ns   NA   NA
|  Pins B7 and A8 are a differential I/O only when DQS# is enabled via MRS
|  If DQS# is disabled, then B7 (DQS) is a single ended I/O and A8 is a NC
|   COMPONENT: MT47H512M4HG_CLP
[Component]   MT47H512M4HG_CLP
[Manufacturer]  Micron Technology, Inc.
[Package]   | 11.5mm x 14mm FBGA with Common Landing Pattern ballout
|variable   typ   min   max
R_pkg   54.8m   21.2m   88.4m
L_pkg   1.45nH   0.81nH   2.43nH
C_pkg   0.14pF   0.11pF   0.19pF
[Pin]  signal_name   model_name   R_pin   L_pin   C_pin
H1   VDD   POWER   70.6m   1.62nH   0.35pF
H2   NF   NF_INPUT   42.9m   1.54nH   0.15pF
H3   VSS   GND   24.2m   1.04nH   NA
H7   VSSQ   GND   54.0m   0.87nH   NA
H8   DQS#   DQS#   46.5m   1.67nH   0.17pF
H9   VDDQ   POWER   56.2m   1.09nH   0.14pF
J1   NF   NF_INPUT   59.1m   2.43nH   0.19pF
J2   VSSQ   GND   54.0m   0.87nH   NA
J3   DM   DM   26.0m   0.87nH   0.12pF
J7   DQS   DQ   24.5m   0.89nH   0.12pF
J8   VSSQ   GND   54.0m   0.87nH   NA
J9   NF   NF_INPUT   66.1m   2.15nH   0.18pF
K1   VDDQ   POWER   56.2m   1.09nH   0.14pF
K2   DQ1   DQ   37.4m   1.46nH   0.14pF
K3   VDDQ   POWER   56.2m   1.09nH   0.14pF
K7   VDDQ   POWER   56.2m   1.09nH   0.14pF
K8   DQ0   DQ   39.3m   2.06nH   0.15pF
C9   VDDQ   POWER   56.2m   1.09nH   0.14pF
L1   NF   NF_INPUT   48.1m   1.92nH   0.16pF
L2   VSSQ   GND   54.0m   0.87nH   NA
L3   DQ3   DQ   25.5m   0.90nH   0.11pF
L7   DQ2   DQ   29.2m   0.88nH   0.12pF
L8   VSSQ   GND   54.0m   0.87nH   NA
L9   NF   NF_INPUT   53.9m   2.02nH   0.18pF
M1   VDDL   POWER   52.2m   2.06nH   0.17pF
M2   VREF   POWER   37.6m   1.47nH   0.14pF
M3   VSS   GND   24.2m   1.04nH   NA
M7   VSSDL   GND   29.5m   1.11nH   NA
M8   CK   CLK   41.6m   1.62nH   0.16pF
M9   VDD   POWER   70.6m   1.62nH   0.35pF
N1   NC   NC
N2   CKE   INPUT   42.1m   1.53nH   0.15pF
N3   WE#   INPUT   88.4m   1.12nH   0.12pF
N7   RAS#   INPUT   29.5m   1.11nH   0.13pF
N8   CK#   CLK   44.7m   1.73nH   0.16pF
N9   ODT   INPUT   58.7m   2.33nH   0.19pF
P1   BA2   INPUT   57.5m   2.14nH   0.18pF
P2   BA0   INPUT   39.0m   1.45nH   0.15pF
P3   BA1   INPUT   24.2m   0.89nH   0.12pF
P7   CAS#   INPUT   22.4m   0.84nH   0.11pF
P8   CS#   INPUT   48.1m   1.53nH   0.15pF
P9   NC   NC
R1   NC   NC
R2   A10   INPUT   40.3m   1.47nH   0.14pF
R3   A1   INPUT   24.3m   0.92nH   0.12pF
R7   A2   INPUT   28.6m   0.93nH   0.12pF
R8   A0   INPUT   37.0m   1.43nH   0.15pF
R9   VDD   POWER   70.6m   1.62nH   0.35pF
T1   VSS   GND   24.2m   1.04nH   NA
T2   A3   INPUT   42.3m   1.60nH   0.15pF
T3   A5   INPUT   27.7m   1.05nH   0.12pF
T7   A6   INPUT   31.8m   1.16nH   0.13pF
T8   A4   INPUT   43.1m   1.64nH   0.16pF
T9   NC   NC
U1   NC   NC
U2   A7   INPUT   41.6m   1.58nH   0.15pF
U3   A9   INPUT   26.0m   0.99nH   0.12pF
U7   A11   INPUT   45.5m   1.63nH   0.15pF
U8   A8   INPUT   64.6m   1.99nH   0.17pF
U9   VSS   GND   24.2m   1.04nH   NA
V1   VDD   POWER   70.6m   1.62nH   0.35pF
V2   A12   INPUT   38.1m   1.45nH   0.15pF
V3   A14   INPUT   21.2m   0.81nH   0.11pF
V7   NC   NC
V8   A13   INPUT   39.8m   1.40nH   0.14pF
|**********************DIFF PIN*********************************************
[Diff_pin]   inv_pin   vdiff   tdelay_typ   tdelay_min   tdelay_max
   M8   N8   .250V   0ns   NA   NA
   J7   H8   .250V   0ns   NA   NA
|  Pins J7 and H8 are a differential I/O only when DQS# is enabled via MRS
|  If DQS# is disabled, then J7 (DQS) is a single ended I/O and H8 is a NC
|   COMPONENT: MT47H256M8HG
[Component]   MT47H256M8HG
[Manufacturer]  Micron Technology, Inc.
[Package]   | 11.5mm x 14mm FBGA
|variable   typ   min   max
R_pkg   54.8m   21.2m   88.4m
L_pkg   1.45nH   0.81nH   2.43nH
C_pkg   0.14pF   0.11pF   0.19pF
[Pin]  signal_name   model_name   R_pin   L_pin   C_pin
A1   VDD   POWER   70.6m   1.62nH   0.35pF
A2   RDQS#   RDQS#   42.9m   1.54nH   0.15pF
A3   VSS   GND   24.2m   1.04nH   NA
A7   VSSQ   GND   54.0m   0.87nH   NA
A8   DQS#   DQS#   46.5m   1.67nH   0.17pF
A9   VDDQ   POWER   56.2m   1.09nH   0.14pF
B1   DQ6   DQ   59.1m   2.43nH   0.19pF
B2   VSSQ   GND   54.0m   0.87nH   NA
B3   DM/RDQS   DM_RDQS   26.0m   0.87nH   0.12pF
B7   DQS   DQ   24.5m   0.89nH   0.12pF
B8   VSSQ   GND   54.0m   0.87nH   NA
B9   DQ7   DQ   66.1m   2.15nH   0.18pF
C1   VDDQ   POWER   56.2m   1.09nH   0.14pF
C2   DQ1   DQ   37.4m   1.46nH   0.14pF
C3   VDDQ   POWER   56.2m   1.09nH   0.14pF
C7   VDDQ   POWER   56.2m   1.09nH   0.14pF
C8   DQ0   DQ   39.3m   2.06nH   0.15pF
C9   VDDQ   POWER   56.2m   1.09nH   0.14pF
D1   DQ4   DQ   48.1m   1.92nH   0.16pF
D2   VSSQ   GND   54.0m   0.87nH   NA
D3   DQ3   DQ   25.5m   0.90nH   0.11pF
D7   DQ2   DQ   29.2m   0.88nH   0.12pF
D8   VSSQ   GND   54.0m   0.87nH   NA
D9   DQ5   DQ   53.9m   2.02nH   0.18pF
E1   VDDL   POWER   52.2m   2.06nH   0.17pF
E2   VREF   POWER   37.6m   1.47nH   0.14pF
E3   VSS   GND   24.2m   1.04nH   NA
E7   VSSDL   GND   29.5m   1.11nH   NA
E8   CK   CLK   41.6m   1.62nH   0.16pF
E9   VDD   POWER   70.6m   1.62nH   0.35pF
F1   NC   NC
F2   CKE0   INPUT   42.1m   1.53nH   0.15pF
F3   WE#   INPUT   88.4m   1.12nH   0.12pF
F7   RAS#   INPUT   29.5m   1.11nH   0.13pF
F8   CK#   CLK   44.7m   1.73nH   0.16pF
F9   ODT0   INPUT   58.7m   2.33nH   0.19pF
G1   BA2   INPUT   57.5m   2.14nH   0.18pF
G2   BA0   INPUT   39.0m   1.45nH   0.15pF
G3   BA1   INPUT   24.2m   0.89nH   0.12pF
G7   CAS#   INPUT   22.4m   0.84nH   0.11pF
G8   CS0#   INPUT   48.1m   1.53nH   0.15pF
G9   NC   NC
H1   NC   NC
H2   A10   INPUT   40.3m   1.47nH   0.14pF
H3   A1   INPUT   24.3m   0.92nH   0.12pF
H7   A2   INPUT   28.6m   0.93nH   0.12pF
H8   A0   INPUT   37.0m   1.43nH   0.15pF
H9   VDD   POWER   70.6m   1.62nH   0.35pF
J1   VSS   GND   24.2m   1.04nH   NA
J2   A3   INPUT   42.3m   1.60nH   0.15pF
J3   A5   INPUT   27.7m   1.05nH   0.12pF
J7   A6   INPUT   31.8m   1.16nH   0.13pF
J8   A4   INPUT   43.1m   1.64nH   0.16pF
J9   NC   NC
K1   NC   NC
K2   A7   INPUT   41.6m   1.58nH   0.15pF
K3   A9   INPUT   26.0m   0.99nH   0.12pF
K7   A11   INPUT   45.5m   1.63nH   0.15pF
K8   A8   INPUT   64.6m   1.99nH   0.17pF
K9   VSS   GND   24.2m   1.04nH   NA
L1   VDD   POWER   70.6m   1.62nH   0.35pF
L2   A12   INPUT   38.1m   1.45nH   0.15pF
L3   A14   INPUT   21.2m   0.81nH   0.11pF
L7   NC   NC
L8   A13   INPUT   39.8m   1.40nH   0.14pF
|**********************DIFF PIN*********************************************
[Diff_pin]   inv_pin   vdiff   tdelay_typ   tdelay_min   tdelay_max
   E8   F8   .250V   0ns   NA   NA
   B7   A8   .250V   0ns   NA   NA
|  Pins B7 and A8 are a differential I/O only when DQS# is enabled via MRS
|  If DQS# is disabled, then B7 (DQS) is a single ended I/O and A8 is a NC
   B3   A2   .250V   0ns   NA   NA
|  Pins B3 and A2 (RDQS,RDQS#) are a differential output only if RDQS and
|  Differential Strobe MRS options are enabled
|   COMPONENT: MT47H256M8HG_CLP
[Component]   MT47H256M8HG_CLP
[Manufacturer]  Micron Technology, Inc.
[Package]   | 11.5mm x 14mm FBGA with Common Landing Pattern ballout
|variable   typ   min   max
R_pkg   54.8m   21.2m   88.4m
L_pkg   1.45nH   0.81nH   2.43nH
C_pkg   0.14pF   0.11pF   0.19pF
[Pin]  signal_name   model_name   R_pin   L_pin   C_pin
H1   VDD   POWER   70.6m   1.62nH   0.35pF
H2   RDQS#   RDQS#   42.9m   1.54nH   0.15pF
H3   VSS   GND   24.2m   1.04nH   NA
H7   VSSQ   GND   54.0m   0.87nH   NA
H8   DQS#   DQS#   46.5m   1.67nH   0.17pF
H9   VDDQ   POWER   56.2m   1.09nH   0.14pF
J1   DQ6   DQ   59.1m   2.43nH   0.19pF
J2   VSSQ   GND   54.0m   0.87nH   NA
J3   DM/RDQS   DM_RDQS   26.0m   0.87nH   0.12pF
J7   DQS   DQ   24.5m   0.89nH   0.12pF
J8   VSSQ   GND   54.0m   0.87nH   NA
J9   DQ7   DQ   66.1m   2.15nH   0.18pF
K1   VDDQ   POWER   56.2m   1.09nH   0.14pF
K2   DQ1   DQ   37.4m   1.46nH   0.14pF
K3   VDDQ   POWER   56.2m   1.09nH   0.14pF
K7   VDDQ   POWER   56.2m   1.09nH   0.14pF
K8   DQ0   DQ   39.3m   2.06nH   0.15pF
K9   VDDQ   POWER   56.2m   1.09nH   0.14pF
L1   DQ4   DQ   48.1m   1.92nH   0.16pF
L2   VSSQ   GND   54.0m   0.87nH   NA
L3   DQ3   DQ   25.5m   0.90nH   0.11pF
L7   DQ2   DQ   29.2m   0.88nH   0.12pF
L8   VSSQ   GND   54.0m   0.87nH   NA
L9   DQ5   DQ   53.9m   2.02nH   0.18pF
M1   VDDL   POWER   52.2m   2.06nH   0.17pF
M2   VREF   POWER   37.6m   1.47nH   0.14pF
M3   VSS   GND   24.2m   1.04nH   NA
M7   VSSDL   GND   29.5m   1.11nH   NA
M8   CK   CLK   41.6m   1.62nH   0.16pF
M9   VDD   POWER   70.6m   1.62nH   0.35pF
N1   NC   NC
N2   CKE   INPUT   42.1m   1.53nH   0.15pF
N3   WE#   INPUT   88.4m   1.12nH   0.12pF
N7   RAS#   INPUT   29.5m   1.11nH   0.13pF
N8   CK#   CLK   44.7m   1.73nH   0.16pF
N9   ODT   INPUT   58.7m   2.33nH   0.19pF
P1   BA2   INPUT   57.5m   2.14nH   0.18pF
P2   BA0   INPUT   39.0m   1.45nH   0.15pF
P3   BA1   INPUT   24.2m   0.89nH   0.12pF
P7   CAS#   INPUT   22.4m   0.84nH   0.11pF
P8   CS#   INPUT   48.1m   1.53nH   0.15pF
P9   NC   NC
R1   NC   NC
R2   A10   INPUT   40.3m   1.47nH   0.14pF
R3   A1   INPUT   24.3m   0.92nH   0.12pF
R7   A2   INPUT   28.6m   0.93nH   0.12pF
R8   A0   INPUT   37.0m   1.43nH   0.15pF
R9   VDD   POWER   70.6m   1.62nH   0.35pF
T1   VSS   GND   24.2m   1.04nH   NA
T2   A3   INPUT   42.3m   1.60nH   0.15pF
T3   A5   INPUT   27.7m   1.05nH   0.12pF
T7   A6   INPUT   31.8m   1.16nH   0.13pF
T8   A4   INPUT   43.1m   1.64nH   0.16pF
T9   NC   NC
U1   NC   NC
U2   A7   INPUT   41.6m   1.58nH   0.15pF
U3   A9   INPUT   26.0m   0.99nH   0.12pF
U7   A11   INPUT   45.5m   1.63nH   0.15pF
U8   A8   INPUT   64.6m   1.99nH   0.17pF
U9   VSS   GND   24.2m   1.04nH   NA
V1   VDD   POWER   70.6m   1.62nH   0.35pF
V2   A12   INPUT   38.1m   1.45nH   0.15pF
V3   A14   INPUT   21.2m   0.81nH   0.11pF
V7   NC   NC
V8   A13   INPUT   39.8m   1.40nH   0.14pF
|**********************DIFF PIN*********************************************
[Diff_pin]   inv_pin   vdiff   tdelay_typ   tdelay_min   tdelay_max
   M8   N8   .250V   0ns   NA   NA
   J7   H8   .250V   0ns   NA   NA
|  Pins J7 and H8 are a differential I/O only when DQS# is enabled via MRS
|  If DQS# is disabled, then J7 (DQS) is a single ended I/O and H8 is a NC
   J3   H2   .250V   0ns   NA   NA
|  Pins H3 and H2 (RDQS,RDQS#) are a differential output only if RDQS and
|  Differential Strobe MRS options are enabled
|   COMPONENT: MT47H128M16HG
[Component]   MT47H128M16HG
[Manufacturer]  Micron Technology, Inc.
[Package]   | 11.5mm x 14mm FBGA
|variable   typ   min   max
R_pkg   38.6m   15.0m   62.2m
L_pkg   1.34nH   0.51nH   2.16nH
C_pkg   0.15pF   0.11pF   0.19pF
[Pin]  signal_name   model_name   R_pin   L_pin   C_pin
A1   VDD   POWER   74.2m   1.09nH   0.33pF
A2   NC   NC
A3   VSS   GND   21.5m   0.66nH   NA
A7   VSSQ   GND   66.3m   0.69nH   NA
A8   UDQS#   DQS#   66.3m   0.69nH   0.12pF
A9   VDDQ   POWER   59.0m   0.75nH   0.14pF
B1   DQ14   DQ   48.9m   1.76nH   0.17pF
B2   VSSQ   GND   66.3m   0.69nH   NA
B3   UDM   DM   19.9m   0.66nH   0.19pF
B7   UDQS   DQ   16.7m   0.56nH   0.12pF
B8   VSSQ   GND   66.3m   0.69nH   NA
B9   DQ15   DQ   62.2m   2.16nH   0.19pF
C1   VDDQ   POWER   59.0m   0.75nH   0.14pF
C2   DQ9   DQ   36.1m   1.20nH   0.14pF
C3   VDDQ   POWER   59.0m   0.75nH   0.14pF
C7   VDDQ   POWER   59.0m   0.75nH   0.14pF
C8   DQ8   DQ   29.4m   1.23nH   0.15pF
C9   VDDQ   POWER   59.0m   0.75nH   0.14pF
D1   DQ12   DQ   50.5m   1.73nH   0.17pF
D2   VSSQ   GND   66.3m   0.69nH   NA
D3   DQ11   DQ   17.0m   0.53nH   0.11pF
D7   DQ10   DQ   15.0m   0.52nH   0.11pF
D8   VSSQ   GND   66.3m   0.69nH   NA
D9   DQ13   DQ   50.0m   1.78nH   0.17pF
E1   VDD   POWER   74.2m   1.09nH   0.33pF
E2   NC   NC
E3   VSS   GND   21.5m   0.66nH   NA
E7   VSSQ   GND   66.3m   0.69nH   NA
E8   LDQS#   DQS#   38.6m   1.21nH   0.15pF
E9   VDDQ   POWER   59.0m   0.75nH   0.14pF
F1   DQ6   DQ   54.0m   1.60nH   0.18pF
F2   VSSQ   GND   66.3m   0.69nH   NA
F3   LDM   DM   19.9m   0.66nH   0.19pF
F7   LDQS   DQ   15.6m   0.52nH   0.11pF
F8   VSSQ   GND   66.3m   0.69nH   NA
F9   DQ7   DQ   40.3m   1.74nH   0.17pF
G1   VDDQ   POWER   59.0m   0.75nH   0.14pF
G2   DQ1   DQ   34.9m   1.09nH   0.14pF
G3   VDDQ   POWER   59.0m   0.75nH   0.14pF
G7   VDDQ   POWER   59.0m   0.75nH   0.14pF
G8   DQ0   DQ   35.5m   1.18nH   0.15pF
G9   VDDQ   POWER   59.0m   0.75nH   0.14pF
H1   DQ4   DQ   39.3m   1.53nH   0.16pF
H2   VSSQ   GND   66.3m   0.69nH   NA
H3   DQ3   DQ   18.1m   0.52nH   0.11pF
H7   DQ2   DQ   16.8m   0.56nH   0.11pF
H8   VSSQ   GND   66.3m   0.69nH   NA
H9   DQ5   DQ   42.6m   1.62nH   0.17pF
J1   VDDL   POWER   47.9m   1.70nH   0.17pF
J2   VREF   POWER   30.3m   1.90nH   0.14pF
J3   VSS   GND   21.5m   0.66nH   NA
J7   VSSDL   GND   24.0m   0.80nH   NA
J8   CK   CLK   38.3m   1.29nH   0.15pF
J9   VDD   POWER   74.2m   1.09nH   0.33pF
K2   CKE   INPUT   36.2m   1.20nH   0.14pF
K3   WE#   INPUT   22.3m   0.69nH   0.12pF
K7   RAS#   INPUT   21.0m   0.69nH   0.12pF
K8   CK#   CLK   36.5m   1.23nH   0.15pF
K9   ODT   INPUT   60.0m   2.21nH   0.19pF
L1   BA2   INPUT   47.0m   1.72nH   0.17pF
L2   BA0   INPUT   35.1m   1.18nH   0.15pF
L3   BA1   INPUT   20.7m   0.59nH   0.11pF
L7   CAS#   INPUT   16.3m   0.53nH   0.11pF
L8   CS#   INPUT   46.2m   1.23nH   0.14pF
L9   NC   NC
M1   NC   NC
M2   A10   INPUT   37.3m   1.18nH   0.14pF
M3   A1   INPUT   17.1m   0.56nH   0.11pF
M7   A2   INPUT   16.7m   0.56nH   0.11pF
M8   A0   INPUT   49.2m   1.21nH   0.15pF
M9   VDD   POWER   74.2m   1.09nH   0.33pF
N1   VSS   GND   21.5m   0.66nH   NA
N2   A3   INPUT   36.2m   1.19nH   0.14pF
N3   A5   INPUT   19.7m   0.63nH   0.12pF
N7   A6   INPUT   18.3m   0.60nH   0.12pF
N8   A4   INPUT   55.1m   1.20nH   0.15pF
N9   NC   NC
P2   A7   INPUT   27.8m   1.06nH   0.14pF
P3   A9   INPUT   16.1m   0.52nH   0.11pF
P7   A11   INPUT   15.9m   0.54nH   0.11pF
P8   A8   INPUT   36.1m   1.21nH   0.15pF
P9   VSS   GND   21.5m   0.66nH   NA
R1   VDD   POWER   74.2m   1.09nH   0.33pF
R2   A12   INPUT   28.6m   1.10nH   0.14pF
R3   A14   INPUT   16.1m   0.56nH   0.11pF
R7   RFU   NC
R8   A13   INPUT   27.7m   1.05nH   0.14pF
|**********************DIFF PIN*********************************************
[Diff_pin]   inv_pin   vdiff   tdelay_typ   tdelay_min   tdelay_max
   B7   A8   .250V   0ns   NA   NA
   F7   E8   .250V   0ns   NA   NA
|  Pins B7 and A8 are a differential I/O only when DQS# is enabled via MRS
|  If DQS# is disabled, then B7(UDQS) is a single ended I/O and A8 is a NC
|  Pins F7 and E8 are a differential I/O only when DQS# is enabled via MRS
|  If DQS# is disabled, then F7(LDQS) is a single ended I/O and E8 is a NC
   J8   K8   .250V   0ns   NA   NA
|   COMPONENT: MT47H128M16HG_CLP
[Component]   MT47H128M16HG_CLP
[Manufacturer]  Micron Technology, Inc.
[Package]   | 11.5mm x 14mm FBGA with Common Landing Pattern ballout
|variable   typ   min   max
R_pkg   38.6m   15.0m   62.2m
L_pkg   1.34nH   0.51nH   2.16nH
C_pkg   0.15pF   0.11pF   0.19pF
[Pin]  signal_name   model_name   R_pin   L_pin   C_pin
D1   VDD   POWER   74.2m   1.09nH   0.33pF
D2   NC   NC
D3   VSS   GND   21.5m   0.66nH   NA
D7   VSSQ   GND   66.3m   0.69nH   NA
D8   UDQS#   DQS#   66.3m   0.69nH   0.12pF
D9   VDDQ   POWER   59.0m   0.75nH   0.14pF
E1   DQ14   DQ   48.9m   1.76nH   0.17pF
E2   VSSQ   GND   66.3m   0.69nH   NA
E3   UDM   DM   19.9m   0.66nH   0.19pF
E7   UDQS   DQ   16.7m   0.56nH   0.12pF
E8   VSSQ   GND   66.3m   0.69nH   NA
E9   DQ15   DQ   62.2m   2.16nH   0.19pF
F1   VDDQ   POWER   59.0m   0.75nH   0.14pF
F2   DQ9   DQ   36.1m   1.20nH   0.14pF
F3   VDDQ   POWER   59.0m   0.75nH   0.14pF
F7   VDDQ   POWER   59.0m   0.75nH   0.14pF
F8   DQ8   DQ   29.4m   1.23nH   0.15pF
F9   VDDQ   POWER   59.0m   0.75nH   0.14pF
G1   DQ12   DQ   50.5m   1.73nH   0.17pF
G2   VSSQ   GND   66.3m   0.69nH   NA
G3   DQ11   DQ   17.0m   0.53nH   0.11pF
G7   DQ10   DQ   15.0m   0.52nH   0.11pF
G8   VSSQ   GND   66.3m   0.69nH   NA
G9   DQ13   DQ   50.0m   1.78nH   0.17pF
H1   VDD   POWER   74.2m   1.09nH   0.33pF
H2   NC   NC
H3   VSS   GND   21.5m   0.66nH   NA
H7   VSSQ   GND   66.3m   0.69nH   NA
H8   LDQS#   DQS#   38.6m   1.21nH   0.15pF
H9   VDDQ   POWER   59.0m   0.75nH   0.14pF
J1   DQ6   DQ   54.0m   1.60nH   0.18pF
J2   VSSQ   GND   66.3m   0.69nH   NA
J3   LDM   DM   19.9m   0.66nH   0.19pF
J7   LDQS   DQ   15.6m   0.52nH   0.11pF
J8   VSSQ   GND   66.3m   0.69nH   NA
J9   DQ7   DQ   40.3m   1.74nH   0.17pF
K1   VDDQ   POWER   59.0m   0.75nH   0.14pF
K2   DQ1   DQ   34.9m   1.09nH   0.14pF
K3   VDDQ   POWER   59.0m   0.75nH   0.14pF
K7   VDDQ   POWER   59.0m   0.75nH   0.14pF
K8   DQ0   DQ   35.5m   1.18nH   0.15pF
K9   VDDQ   POWER   59.0m   0.75nH   0.14pF
L1   DQ4   DQ   39.3m   1.53nH   0.16pF
L2   VSSQ   GND   66.3m   0.69nH   NA
L3   DQ3   DQ   18.1m   0.52nH   0.11pF
L7   DQ2   DQ   16.8m   0.56nH   0.11pF
L8   VSSQ   GND   66.3m   0.69nH   NA
L9   DQ5   DQ   42.6m   1.62nH   0.17pF
M1   VDDL   POWER   47.9m   1.70nH   0.17pF
M2   VREF   POWER   30.3m   1.90nH   0.14pF
M3   VSS   GND   21.5m   0.66nH   NA
M7   VSSDL   GND   24.0m   0.80nH   NA
M8   CK   CLK   38.3m   1.29nH   0.15pF
M9   VDD   POWER   74.2m   1.09nH   0.33pF
N2   CKE   INPUT   36.2m   1.20nH   0.14pF
N3   WE#   INPUT   22.3m   0.69nH   0.12pF
N7   RAS#   INPUT   21.0m   0.69nH   0.12pF
N8   CK#   CLK   36.5m   1.23nH   0.15pF
N9   ODT   INPUT   60.0m   2.21nH   0.19pF
P1   BA2   INPUT   47.0m   1.72nH   0.17pF
P2   BA0   INPUT   35.1m   1.18nH   0.15pF
P3   BA1   INPUT   20.7m   0.59nH   0.11pF
P7   CAS#   INPUT   16.3m   0.53nH   0.11pF
P8   CS#   INPUT   46.2m   1.23nH   0.14pF
P9   NC   NC
R1   NC   NC
R2   A10   INPUT   37.3m   1.18nH   0.14pF
R3   A1   INPUT   17.1m   0.56nH   0.11pF
R7   A2   INPUT   16.7m   0.56nH   0.11pF
R8   A0   INPUT   49.2m   1.21nH   0.15pF
R9   VDD   POWER   74.2m   1.09nH   0.33pF
T1   VSS   GND   21.5m   0.66nH   NA
T2   A3   INPUT   36.2m   1.19nH   0.14pF
T3   A5   INPUT   19.7m   0.63nH   0.12pF
T7   A6   INPUT   18.3m   0.60nH   0.12pF
T8   A4   INPUT   55.1m   1.20nH   0.15pF
T9   NC   NC
U2   A7   INPUT   27.8m   1.06nH   0.14pF
U3   A9   INPUT   16.1m   0.52nH   0.11pF
U7   A11   INPUT   15.9m   0.54nH   0.11pF
U8   A8   INPUT   36.1m   1.21nH   0.15pF
U9   VSS   GND   21.5m   0.66nH   NA
V1   VDD   POWER   74.2m   1.09nH   0.33pF
V2   A12   INPUT   28.6m   1.10nH   0.14pF
V3   A14   INPUT   16.1m   0.56nH   0.11pF
V7   RFU   NC
V8   A13   INPUT   27.7m   1.05nH   0.14pF
|**********************DIFF PIN*********************************************
[Diff_pin]   inv_pin   vdiff   tdelay_typ   tdelay_min   tdelay_max
   E7   D8   .250V   0ns   NA   NA
   J7   H8   .250V   0ns   NA   NA
|  Pins E7 and D8 are a differential I/O only when DQS# is enabled via MRS
|  If DQS# is disabled, then E7(UDQS) is a single ended I/O and D8 is a NC
|  Pins J7 and H8 are a differential I/O only when DQS# is enabled via MRS
|  If DQS# is disabled, then J7(LDQS) is a single ended I/O and H8 is a NC
   M8   N8   .250V   0ns   NA   NA
|   Model Selector
[Model Selector] INPUT
IN_533   Input model for 400/533 speed grade
IN_800   Input model for 667/800 speed grade
[Model Selector] CLK
CLKIN_533   Clock model for 400/533 speed grade
CLKIN_800   Clock model for 667/800 speed grade
[Model Selector] NF_INPUT
NF_IN_533   Non_functioning model for DQs
NF_IN_800   Non_functioning model for DQs
[Model Selector] RDQS#
NF_IN_533   Not Used if either RDQS or Diff. Strobe are disabled
RDQS_FULL_533   Full-Strength Output Driver with no ODT
RDQS_HALF_533   Reduced-Strength Output Driver with no ODT
NF_IN_800   Not Used if either RDQS or Diff. Strobe are disabled
RDQS_FULL_800   Full-Strength Output Driver with no ODT
RDQS_HALF_800   Reduced-Strength Output Driver with no ODT
[Model Selector] DM_RDQS
DM_IN_533   DM Input model
DM_ODT50_533   DM Input model with 50 Ohm ODT Submodel
DM_ODT75_533   DM Input model with 75 Ohm ODT Submodel
DM_ODT150_533   DM Input model with 150 Ohm ODT Submodel
RDQS_FULL_533   Full-Strength Output Driver if RDQS is enabled with no ODT
RDQS_HALF_533   Reduced-Strength Output Driver if RDQS is enabled with no ODT
DM_IN_800   DM Input model
DM_ODT50_800   DM Input model with 50 Ohm ODT Submodel
DM_ODT75_800   DM Input model with 75 Ohm ODT Submodel
DM_ODT150_800   DM Input model with 150 Ohm ODT Submodel
RDQS_FULL_800   Full-Strength Output Driver if RDQS is enabled with no ODT
RDQS_HALF_800   Reduced-Strength Output Driver if RDQS is enabled with no ODT
[Model Selector] DM
DM_IN_533   DM input model
DM_ODT50_533   DM Input model with 50 Ohm ODT Submodel
DM_ODT75_533   DM Input model with 75 Ohm ODT Submodel
DM_ODT150_533   DM Input model with 150 Ohm ODT Submodel
DM_IN_800   DM input model
DM_ODT50_800   DM Input model with 50 Ohm ODT Submodel
DM_ODT75_800   DM Input model with 75 Ohm ODT Submodel
DM_ODT150_800   DM Input model with 150 Ohm ODT Submodel
[Model Selector] DQ
DQ_FULL_533   Full-Strength IO Driver with no ODT
DQ_FULL_ODT50_533   Full-Strength IO Driver with 50 Ohm ODT Submodel
DQ_FULL_ODT75_533   Full-Strength IO Driver with 75 Ohm ODT Submodel
DQ_FULL_ODT150_533   Full-Strength IO Driver with 150 Ohm ODT Submodel
DQ_HALF_533   Reduced-Strength IO Driver with no ODT
DQ_HALF_ODT50_533   Reduced-Strength IO Driver with 50 Ohm ODT Submodel
DQ_HALF_ODT75_533   Reduced-Strength IO Driver with 75 Ohm ODT Submodel
DQ_HALF_ODT150_533   Reduced-Strength IO Driver with 150 Ohm ODT Submodel
DQ_FULL_800   Full-Strength IO Driver with no ODT
DQ_FULL_ODT50_800   Full-Strength IO Driver with 50 Ohm ODT Submodel
DQ_FULL_ODT75_800   Full-Strength IO Driver with 75 Ohm ODT Submodel
DQ_FULL_ODT150_800   Full-Strength IO Driver with 150 Ohm ODT Submodel
DQ_HALF_800   Reduced-Strength IO Driver with no ODT
DQ_HALF_ODT50_800   Reduced-Strength IO Driver with 50 Ohm ODT Submodel
DQ_HALF_ODT75_800   Reduced-Strength IO Driver with 75 Ohm ODT Submodel
DQ_HALF_ODT150_800   Reduced-Strength IO Driver with 150 Ohm ODT Submodel
[Model Selector] DQS#
DQ_FULL_533   Full-Strength IO Driver with no ODT
DQ_FULL_ODT50_533   Full-Strength IO Driver with 50 Ohm ODT Submodel
DQ_FULL_ODT75_533   Full-Strength IO Driver with 75 Ohm ODT Submodel
DQ_FULL_ODT150_533   Full-Strength IO Driver with 150 Ohm ODT Submodel
DQ_HALF_533   Reduced-Strength IO Driver with no ODT
DQ_HALF_ODT50_533   Reduced-Strength IO Driver with 50 Ohm ODT Submodel
DQ_HALF_ODT75_533   Reduced-Strength IO Driver with 75 Ohm ODT Submodel
DQ_HALF_ODT150_533   Reduced-Strength IO Driver with 150 Ohm ODT Submodel
NF_IN_533   (Use to disable DQS#)
DQ_FULL_800   Full-Strength IO Driver with no ODT
DQ_FULL_ODT50_800   Full-Strength IO Driver with 50 Ohm ODT Submodel
DQ_FULL_ODT75_800   Full-Strength IO Driver with 75 Ohm ODT Submodel
DQ_FULL_ODT150_800   Full-Strength IO Driver with 150 Ohm ODT Submodel
DQ_HALF_800   Reduced-Strength IO Driver with no ODT
DQ_HALF_ODT50_800   Reduced-Strength IO Driver with 50 Ohm ODT Submodel
DQ_HALF_ODT75_800   Reduced-Strength IO Driver with 75 Ohm ODT Submodel
DQ_HALF_ODT150_800   Reduced-Strength IO Driver with 150 Ohm ODT Submodel
NF_IN_800   (Use to disable DQS#)
| Models and submodels in the file (40): DQ_FULL_533 (I/O), DQ_FULL_ODT50_533 (I/O), DQ_FULL_ODT75_533 (I/O), DQ_FULL_ODT150_533 (I/O), DQ_HALF_533 (I/O), DQ_HALF_ODT50_533 (I/O), DQ_HALF_ODT75_533 (I/O), DQ_HALF_ODT150_533 (I/O), RDQS_FULL_533 (3-state), RDQS_HALF_533 (3-state), DM_IN_533 (Input), DM_ODT50_533 (Input), DM_ODT75_533 (Input), DM_ODT150_533 (Input), IN_533 (Input), CLKIN_533 (Input), NF_IN_533 (Terminator), DQ_FULL_800 (I/O), DQ_FULL_ODT50_800 (I/O), DQ_FULL_ODT75_800 (I/O), DQ_FULL_ODT150_800 (I/O), DQ_HALF_800 (I/O), DQ_HALF_ODT50_800 (I/O), DQ_HALF_ODT75_800 (I/O), DQ_HALF_ODT150_800 (I/O), RDQS_FULL_800 (3-state), RDQS_HALF_800 (3-state), DM_IN_800 (Input), DM_ODT50_800 (Input), DM_ODT75_800 (Input), DM_ODT150_800 (Input), IN_800 (Input), CLKIN_800 (Input), NF_IN_800 (Terminator), 50ohm_ODT_533 (Dynamic_clamp), 75ohm_ODT_533 (Dynamic_clamp), 150ohm_ODT_533 (Dynamic_clamp), 50ohm_ODT_800 (Dynamic_clamp), 75ohm_ODT_800 (Dynamic_clamp), 150ohm_ODT_800 (Dynamic_clamp)
