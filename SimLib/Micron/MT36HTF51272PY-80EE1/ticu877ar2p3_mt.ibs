| ticu877ar2p3.ibs - Micron MDG Simulation Model
| Component   VDD   Package
| TICDCU877AGQL_R2P3  1.8   52-Ball uBGA
| TICDCU877ARTB_R2P3  1.8   40-pin  MLF
|   This file is an IBIS representation of the   |
|   CDCU877A provided by Texas Instruments   |
| This file contains preliminary package information for the following types:
|  uBGA 52-ball (GQL) package as [Component] cdcu877agql
|   MLF 40-pin  (RTB) package as [Component] cdcu877artb
|=================== Header Section -------------------------------------------|
[IBIS Ver]   3.2
[File Name]   ticu877ar2p3_mt.ibs
[File Rev]   2.3
[Date]   16 Apr 2004 | Last modified
|   20 Aug 2002 | Created
[Source]   This file originated at Texas Instruments
|   this file was generated based on simulation results of TI-Spice
|REVISON LOG:02 initial version
|   03 completely revised new model by Product Engineering
|   04 added package designator for bga, mlf package and combined them
|   to one model. Corrected CK/CK- to reflect passive pull-down.
|   05 added rising and falling waveforms.
|   06 new ouput buffers.
|   07 corrected ramp rates
|   08 CDCU877 PLL revised for A-DIE and C-DIE characteristics
|   Package parasitics added for BGA package.
|   09 Added per pin package paracitics for uBGA and MLF package,
|   changed componnent name to "RTB" for MLF-package,
|   corrected differential pin assignment.
|   Removed A-DIE references.
|   12 Correlated to real silicon with 2pF load und lossy option
|   enabled in linesim.
|   14 Corrected slew rate to latest CHAR-DATA
[Notes]   Micron Changes: 11/07/2007 (jdbutterfiel x82742)
   - Removed transistor leakage current from Input model
   POWER Clamp curves
   - Corrected pin mapping for FBGA ball out as per the
   datasheet
   - Corrected Rising Waveform to start at t=0
[Disclaimer]
(C) Copyright Texas Instruments Incorporated 2003
                All rights reserved
  Texas Instruments Incorporated hereby grants the user of this IBIS
model a non-exclusive, nontransferable license to use this IBIS model
under the following terms.  Before using this IBIS model, the user
should read this license.  If the user does not accept these terms,
the IBIS model should be returned to Texas Instruments within 30 days.
  The user is granted this license only to use the IBIS model and
is not granted rights to sell, load, rent, lease or license the IBIS
model in whole or in part, or in modified form to anyone other than
user.  User may modify the IBIS model to suit its specific applications
but rights to derivative works and such modifications shall belong to
Texas Instruments.
  This IBIS model is provided on an "AS IS" basis and Texas Instruments
makes absolutely no warranty with respect to the information contained
herein.  TEXAS INSTRUMENTS DISCLAIMS AND CUSTOMER WAIVES ALL WARRANTIES,
EXPRESS OR IMPLIED, INCLUDING WARRANTIES OF MERCHANTABILITY OR FITNESS
FOR A PARTICULAR PURPOSE. The entire risk as to quality and performance
is with the Customer. ACCORDINGLY, IN NO EVENT SHALL THE COMPANY BE LIABLE
FOR ANY DAMAGES, WHETHER IN CONTRACT OR TORT,INCLUDING ANY LOST PROFITS
OR OTHER INCIDENTAL, CONSEQUENTIAL, EXEMPLARY, OR PUNITIVE DAMAGES ARISING
OUT OF THE USE OR APPLICATION OF THE IBIS model provided in this package.
Further, Texas Instruments reserves the right to discontinue or make changes
without notice to any product herein to improve reliability, function, or
design. Texas Instruments does not convey any license under patent rights
or any other intellectual property rights, including those of third parties.
Contact Texas Instruments at ATTN: HPA-High Speed Communication & Control, HSCC
[Copyright]   Copyright (C)2003 Texas Instruments, All Rights Reserved
|------------------- End of Header Section ====================================|
|=================== Component Section ----------------------------------------|
| Component: TICDCU877AGQL_R2P3, 52-ball, uBGA
[Component]   TICDCU877AGQL_R2P3   |Name of Device
[Manufacturer]  Texas Instruments
[Package]
|   typ   min   max
R_pkg   0.12Ohm   0.05Ohm   0.30Ohm
L_pkg   2.38nH   1.13nH   5.66nH
C_pkg   0.11pF   0.04pF   0.47pF
|pinout for uBGA package
[Pin] signal_name  model_name   R_pin   L_pin   C_pin
A1   Y1   Outbuf1   0.131Ohm   2.474nH   0.052pF
A2   Y0   Outbuf1   0.124Ohm   2.345nH   0.061pF
A3   Y0-   Outbuf1   0.122Ohm   2.306nH   0.061pF
A4   Y5-   Outbuf1   0.123Ohm   2.322nH   0.061pF
A5   Y5   Outbuf1   0.125Ohm   2.367nH   0.060pF
A6   Y6   Outbuf1   0.136Ohm   2.555nH   0.052pF
B1   Y1-   Outbuf1   0.129Ohm   2.444nH   0.052pF
B2   GND   GND   0.122Ohm   2.311nH   0.053pF
B3   GND   GND   0.071Ohm   1.447nH   0.220pF
B4   GND   GND   0.162Ohm   3.098nH   0.120pF
B5   GND   GND   0.123Ohm   2.340nH   0.053pF
B6   Y6-   Outbuf1   0.134Ohm   2.524nH   0.053pF
C1   Y2-   Outbuf1   0.114Ohm   2.285nH   0.085pF
C2   GND   GND   0.080Ohm   2.098nH   0.257pF
C3   NC   NC
C4   NC   NC
C5   GND   GND   0.088Ohm   1.872nH   0.139pF
C6   Y7-   Outbuf1   0.106Ohm   2.129nH   0.083pF
D1   Y2   Outbuf1   0.094Ohm   1.872nH   0.079pF
D2   VDDQ   POWER   0.114Ohm   2.881nH   0.188pF
D3   VDDQ   POWER   0.159Ohm   3.476nH   0.128pF
D4   VDDQ   POWER   0.134Ohm   3.050nH   0.200pF
D5   OS   Control   0.300Ohm   5.663nH   0.467pF
D6   Y7   Outbuf1   0.095Ohm   1.887nH   0.079pF
E1   CK   Inbuf_PD   0.087Ohm   1.754nH   0.074pF
E2   VDDQ   POWER   0.163Ohm   3.559nH   0.133pF
E3   NC   NC
E4   NC   NC
E5   VDDQ   POWER   0.108Ohm   2.318nH   0.122pF
E6   FBIN   Inbuf   0.088Ohm   1.784nH   0.078pF
F1   CK-   Inbuf_PD   0.088Ohm   1.761nH   0.078pF
F2   VDDQ   POWER   0.112Ohm   2.382nH   0.127pF
F3   NC   NC
F4   NC   NC
F5   OE   Control   0.122Ohm   2.504nH   0.346pF
F6   FBIN-   Inbuf   0.089Ohm   1.779nH   0.075pF
G1   AGND   GND   0.051Ohm   1.129nH   0.079pF
G2   VDDQ   POWER   0.102Ohm   2.270nH   0.164pF
G3   VDDQ   POWER   0.163Ohm   3.559nH   0.133pF
G4   VDDQ   POWER   0.165Ohm   2.258nH   0.300pF
G5   VDDQ   POWER   0.159Ohm   3.476nH   0.128pF
G6   FBOUT-   Outbuf1   0.100Ohm   1.961nH   0.074pF
H1   AVDD   POWER   0.058Ohm   1.250nH   0.088pF
H2   GND   GND   0.162Ohm   3.098nH   0.120pF
H3   NC   NC
H4   NC   NC
H5   GND   GND   0.153Ohm   3.024nH   0.173pF
H6   FBOUT   Outbuf1   0.110Ohm   2.156nH   0.104pF
J1   Y3   Outbuf1   0.134Ohm   2.519nH   0.052pF
J2   GND   GND   0.122Ohm   2.311nH   0.053pF
J3   GND   GND   0.162Ohm   3.098nH   0.120pF
J4   GND   GND   0.122Ohm   2.311nH   0.053pF
J5   GND   GND   0.071Ohm   1.447nH   0.220pF
J6   Y8   Outbuf1   0.136Ohm   2.481nH   0.044pF
K1   Y3-   Outbuf1   0.134Ohm   2.519nH   0.052pF
K2   Y4-   Outbuf1   0.124Ohm   2.347nH   0.060pF
K3   Y4   Outbuf1   0.122Ohm   2.307nH   0.060pF
K4   Y9   Outbuf1   0.123Ohm   2.322nH   0.060pF
K5   Y9-   Outbuf1   0.126Ohm   2.381nH   0.060pF
K6   Y8-   Outbuf1   0.140Ohm   2.627nH   0.051pF
[Diff_Pin]  inv_pin  vdiff   tdelay_typ  tdelay_min  tdelay_max
| The '+' pin is   Diff_pin,   the '-' pin is the   Inv_pin
| Receiver Pins  |  Receiver Vth = +/-300mV (DC, AC=0.6V)
E1   F1   0.3V   0ns   0ns   0ns   | CK  / CK-
E6   F6   0.3V   0ns   0ns   0ns   | FBIN/ FBIN-
| Driver Pins   |  Rload = xx ohm at xx termination
D1   C1   NA   0ns   0ns   0ns   | Y2 / Y2-
A1   B1   NA   0ns   0ns   0ns   | Y1 / Y1-
J1   K1   NA   0ns   0ns   0ns   | Y3 / Y3-
A2   A3   NA   0ns   0ns   0ns   | Y0 / Y0-
A5   A4   NA   0ns   0ns   0ns   | Y5 / Y5-
A6   B6   NA   0ns   0ns   0ns   | Y6 / Y6-
D6   C6   NA   0ns   0ns   0ns   | Y7 / Y7-
J6   K6   NA   0ns   0ns   0ns   | Y8 / Y8-
K4   K5   NA   0ns   0ns   0ns   | Y9 / Y9-
K3   K2   NA   0ns   0ns   0ns   | Y4 / Y4-
H6   G6   NA   0ns   0ns   0ns   | FBOUT / FBOUT-
[Model Selector]   Outbuf1
CDCU877C1_PLL C-DIE PLL_MODE (no buffer delay, no shift between splits in VT)
| Component: TICDCU877ARTB_R2P3 40-pin MLF
[Component]   TICDCU877ARTB_R2P3   |Name of Device
[Manufacturer]  Texas Instruments
[Package]
|   typ   min   max
R_pkg   0.12Ohm   0.06Ohm   0.15Ohm
L_pkg   1.17nH   0.59nH   1.50nH
C_pkg   0.07pF   0.03pF   0.11pF
|pinning for MLF40 package
[Pin] signal_name  model_name   R_pin   L_pin   C_pin
  1   VDDQ   POWER   0.071Ohm   0.706nH   0.095pF
  2   Y2-   Outbuf2   0.133Ohm   1.319nH   0.080pF
  3   Y2   Outbuf2   0.124Ohm   1.229nH   0.111pF
  4   CK   Inbuf_PD   0.121Ohm   1.194nH   0.099pF
  5   CK-   Inbuf_PD   0.117Ohm   1.156nH   0.060pF
  6   VDDQ   POWER   0.117Ohm   1.157nH   0.070pF
  7   AGND   GND   0.060Ohm   0.592nH   0.071pF
  8   AVDD   POWER   0.062Ohm   0.609nH   0.072pF
  9   VDDQ   POWER   0.064Ohm   0.632nH   0.074pF
 10   GND   GND   0.143Ohm   1.419nH   0.078pF
 11   Y3   Outbuf2   0.146Ohm   1.442nH   0.071pF
 12   Y3-   Outbuf2   0.133Ohm   1.321nH   0.048pF
 13   Y4-   Outbuf2   0.128Ohm   1.267nH   0.085pF
 14   Y4   Outbuf2   0.121Ohm   1.195nH   0.063pF
 15   VDDQ   POWER   0.117Ohm   1.157nH   0.056pF
 16   Y9   Outbuf2   0.117Ohm   1.156nH   0.055pF
 17   Y9-   Outbuf2   0.121Ohm   1.195nH   0.056pF
 18   Y8-   Outbuf2   0.125Ohm   1.233nH   0.057pF
 19   Y8   Outbuf2   0.134Ohm   1.325nH   0.054pF
 20   VDDQ   POWER   0.071Ohm   0.700nH   0.076pF
 21   OS   Control   0.145Ohm   1.439nH   0.077pF
 22   OE   Control   0.133Ohm   1.318nH   0.084pF
 23   VDDQ   POWER   0.124Ohm   1.229nH   0.073pF
 24   FBOUT   Outbuf2   0.118Ohm   1.173nH   0.061pF
 25   FBOUT-   Outbuf2   0.116Ohm   1.152nH   0.073pF
 26   FBIN-   Inbuf   0.117Ohm   1.157nH   0.070pF
 27   FBIN   Inbuf   0.121Ohm   1.196nH   0.074pF
 28   VDDQ   POWER   0.128Ohm   1.272nH   0.075pF
 29   Y7   Outbuf2   0.139Ohm   1.375nH   0.081pF
 30   Y7-   Outbuf2   0.151Ohm   1.500nH   0.041pF
 31   VDDQ   POWER   0.071Ohm   0.705nH   0.081pF
 32   Y6-   Outbuf2   0.133Ohm   1.316nH   0.097pF
 33   Y6   Outbuf2   0.124Ohm   1.227nH   0.060pF
 34   Y5   Outbuf2   0.120Ohm   1.192nH   0.049pF
 35   Y5-   Outbuf2   0.117Ohm   1.156nH   0.054pF
 36   VDDQ   POWER   0.117Ohm   1.158nH   0.049pF
 37   Y0-   Outbuf2   0.121Ohm   1.198nH   0.033pF
 38   Y0   Outbuf2   0.129Ohm   1.274nH   0.025pF
 39   Y1   Outbuf2   0.134Ohm   1.330nH   0.101pF
 40   Y1-   Outbuf2   0.146Ohm   1.447nH   0.084pF
Pad   GND   GND   0.007Ohm   0.064nH   0.355pF
[Diff_Pin]  inv_pin  vdiff   tdelay_typ  tdelay_min  tdelay_max
| The '+' pin is   Diff_pin,   the '-' pin is the   Inv_pin
| Receiver Pins  |  Receiver Vth = +/-300mV (DC, AC=0.6V)
4   5   0.3V   0ns   0ns   0ns   | CK  / CK-
27   26   0.3V   0ns   0ns   0ns   | FBIN/ FBIN-
| Driver Pins   |  Rload = xx ohm at xx termination
3   2   NA   0ns   0ns   0ns   | Y2 / Y2-
11   12   NA   0ns   0ns   0ns   | Y3 / Y3-
14   13   NA   0ns   0ns   0ns   | Y4 / Y4-
16   17   NA   0ns   0ns   0ns   | Y9 / Y9-
19   18   NA   0ns   0ns   0ns   | Y8 / Y8-
24   25   NA   0ns   0ns   0ns   | FBOUT / FBOUT-
29   30   NA   0ns   0ns   0ns   | Y7 / Y7-
33   32   NA   0ns   0ns   0ns   | Y6 / Y6-
34   35   NA   0ns   0ns   0ns   | Y5 / Y5-
38   37   NA   0ns   0ns   0ns   | Y0 / Y0-
39   40   NA   0ns   0ns   0ns   | Y1 / Y1-
|------------------- End of Component Section ==============================
[Model Selector]   Outbuf2
CDCU877C1_PLL C-DIE PLL_MODE (no buffer delay, no shift between splits in VT)
| Models and submodels in the file (4): Inbuf (Input), Inbuf_PD (Input), Control (Input), CDCU877C1_PLL (Output)
