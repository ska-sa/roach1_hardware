| u48b.ibs * IBIS 4.0 Model
| 1Gb DDR-2 SDRAM - Die Revision "E"
| This Model is valid for Commercial Temperature Range 0C<=Ta< 85C
| Valid for DDR2-400/533/667/800/1066 operation
| Models *_533 are applicable for speed grade  400/533 Mbps
| Models *_667 are applicable for speed grade  667 Mbps
| Models *_1066 are applicable for speed grade 800/1066 Mbps
|  Part Number   VDD/VDDQ   Architecture   Package
| MT47H256M4HQ   1.8V/1.8V   256Meg x 4   60-Ball FBGA
| MT47H256M4HQ_CLP  1.8V/1.8V   256Meg x 4   Common Landing Pattern
| MT47H128M8HQ   1.8V/1.8V   128Meg x 8   60-Ball FBGA
| MT47H128M8HQ_CLP  1.8V/1.8V   128Meg x 8   Common Landing Pattern
| MT47H64M16HR   1.8V/1.8V   64Meg x 16   84-Ball FBGA
| MT47H64M16HR_CLP  1.8V/1.8V   64Meg x 16   Common Landing Pattern
[IBIS Ver]   4.0
[File name]   u48b.ibs
[Date]   06/21/2007
[File Rev]   2.1
[Source]   From silicon level SPICE model at Micron Technology, Inc.
   For support e-mail modelsupport@micron.com
[Notes]   Revision History:
   Rev 1.0: 07/05/2006
   - First revision not matched to silicon measurements
   - This IBIS file uses sub-model keyword to model the
   DDR-2 On-die Termination(ODT) charcaterstics.
   - The C_comp value in DQ model is set to match the input
   state of the DQ I/O as measured from the HSPICE model.
   Due to the C_comp differences between the DQ model and the
   DQ_ODT* models, the output characteristics of the
   models will look different when simulated. To match most
   closely with the HSPICE model, simulate with the DQFULL
   or DQHALF model for ALL Output simulations.  Use the ODT
   models ONLY for Input simulations.
   Rev 1.1: 07/21/2006
   - Corrected the [Add Submodel] section in DQHALF_ODT*
   models
   Rev 1.2: 11/01/2006
   - Added the 667/800 speed grade models.
   - Updated the c_comp data based on latest measurement
   - Regenrated Ibis model from latest parasitic netlist
   - For 667/800 models, minimum (slow) and typical corner
   use fast process models
   - Models for 400, 533,667,800 speed grades included,
   selected through [Model Selector]. Models *_667 are
   applicable for speed grade 400/533/667 Mbps and models
   *_1066 are applicable for speed grade 800/1066 Mbps
   Rev 2.0:01/26/2007
   - Model data matched to silicon
   - Regenerated Ibis data using latest parasitic netlist
   - Updated the c_comp data based on latest measurement
   - For 667/800 models, minimum (slow) and typical corner
   use typical process models
   - IQ SUMMARY: Overall Quality of component and models Level
   2b. See Micron IBIS Model Quality Report for full IQ SUMMARY
   Rev 2.1:06/21/2007
   - Changed 800 speed models to 1066 speed models
   and created new models for 667
   - Minimum (slow) and typical corner in 1066 models
   use typical process models
   - typ and slow corner V-t curves in DQ_*_667 models
   are shifted by -200ps and -500ps relative to strong corner
   v-t curve to contain all 3 corners within 1.5ns window
   - typ and slow corner V-t curves in DQFULL_*_1066 models
   are shifted by -300ps and -400ps relative to strong corner
   v-t curve to contain all 3 corners within 0.938ns window
   - Due to the shift in typ and slow corner, the v-t curves
   may overlap each other. This does not effect the accuracy
   of the ibis data.
[Disclaimer]  This software code and all associated documentation, comments
              or other information (collectively "Software") is provided
              "AS IS" without warranty of any kind. MICRON TECHNOLOGY, INC.
              ("MTI") EXPRESSLY DISCLAIMS ALL WARRANTIES EXPRESS OR IMPLIED,
              INCLUDING BUT NOT LIMITED TO, NONINFRINGEMENT OF THIRD PARTY
              RIGHTS, AND ANY IMPLIED WARRANTIES OF MERCHANTABILITY OR
              FITNESS FOR ANY PARTICULAR PURPOSE. MTI DOES NOT WARRANT THAT
              THE SOFTWARE WILL MEET YOUR REQUIREMENTS, OR THAT THE
              OPERATION OF THE SOFTWARE WILL BE UNINTERRUPTED OR ERROR-FREE.
              FURTHERMORE, MTI DOES NOT MAKE ANY REPRESENTATIONS REGARDING
              THE USE OR THE RESULTS OF THE USE OF THE SOFTWARE IN TERMS OF
              ITS CORRECTNESS, ACCURACY, RELIABILITY, OR OTHERWISE. THE
              ENTIRE RISK ARISING OUT OF USE OR PERFORMANCE OF THE SOFTWARE
              REMAINS WITH YOU. IN NO EVENT SHALL MTI, ITS AFFILIATED
              COMPANIES OR THEIR SUPPLIERS BE LIABLE FOR ANY DIRECT,
              INDIRECT, CONSEQUENTIAL, INCIDENTAL, OR SPECIAL DAMAGES
              (INCLUDING, WITHOUT LIMITATION, DAMAGES FOR LOSS OF PROFITS,
              BUSINESS INTERRUPTION, OR LOSS OF INFORMATION) ARISING OUT OF
              YOUR USE OF OR INABILITY TO USE THE SOFTWARE, EVEN IF MTI HAS
              BEEN ADVISED OF THE POSSIBILITY OF SUCH DAMAGES. Because some
              jurisdictions prohibit the exclusion or limitation of
              liability for consequential or incidental damages, the above
              limitation may not apply to you.
[Copyright]   Copyright 2006 Micron Technology, Inc. All rights reserved.
|   COMPONENT: MT47H256M4HQ (60-Ball FBGA, x4)
[Component]   MT47H256M4HQ
[Manufacturer]  Micron Technology,Inc.
[Package]
|   typ   min   max
R_pkg   36.92m   19.36m   76.39m
L_pkg   1.31nH   0.63nH   2.77nH
C_pkg   0.11pF   0.08pF   0.18pF
[Pin]   signal_name model_name   R_pin   L_pin   C_pin
A1   VDD   POWER   28.06m   0.83nH   0.22pF
A2   NC   NF_INPUT   35.40m   1.33nH   0.10pF
A3   VSS   GND   10.78m   0.23nH   NA
A7   VSSQ   GND   17.01m   0.44nH   NA
A8   NU_DQS#   DQS#   45.34m   1.65nH   0.10pF
A9   VDDQ   POWER   1.04m   0.03nH   0.12pF
B1   NF   NF_INPUT   53.39m   1.95nH   0.14pF
B2   VSSQ   GND   3.15m   0.10nH   NA
B3   DM   DM   31.00m   0.84nH   0.11pF
B7   DQS   DQ   31.08m   1.05nH   0.12pF
B8   VSSQ   GND   43.72m   1.57nH   NA
B9   NF   NF_INPUT   70.83m   2.60nH   0.17pF
C1   VDDQ   POWER   27.86m   0.84nH   0.12pF
C2   DQ1   DQ   35.22m   1.30nH   0.11pF
C3   VDDQ   POWER   18.81m   0.66nH   0.12pF
C7   VDDQ   POWER   12.88m   0.29nH   0.12pF
C8   DQ0   DQ   70.15m   2.48nH   0.17pF
C9   VDDQ   POWER   25.92m   0.66nH   0.12pF
D1   NF   NF_INPUT   45.60m   1.76nH   0.13pF
D2   VSSQ   GND   21.17m   0.63nH   NA
D3   DQ3   DQ   31.46m   0.86nH   0.09pF
D7   DQ2   DQ   27.50m   0.80nH   0.09pF
D8   VSSQ   GND   21.17m   0.63nH   NA
D9   NF   NF_INPUT   76.39m   2.77nH   0.18pF
E1   VDDL   POWER   50.85m   1.96nH   0.14pF
E2   VREF   POWER   37.22m   1.41nH   0.12pF
E3   VSS   GND   2.34m   0.05nH   NA
E7   VSSDL   GND   28.52m   1.05nH   NA
E8   CK   CLKIN   41.35m   1.55nH   0.13pF
E9   VDD   POWER   7.49m   0.24nH   0.22pF
F2   CKE   INPUT   39.34m   1.48nH   0.12pF
F3   WE#   INPUT   24.58m   0.89nH   0.09pF
F7   RAS#   INPUT   25.78m   0.94nH   0.09pF
F8   CK#   CLKIN   42.93m   1.55nH   0.12pF
F9   ODT   INPUT   50.23m   1.92nH   0.14pF
G1   BA2   INPUT   49.69m   1.87nH   0.14pF
G2   BA0   INPUT   39.93m   1.48nH   0.12pF
G3   BA1   INPUT   25.65m   0.89nH   0.09pF
G7   CAS#   INPUT   22.15m   0.79nH   0.09pF
G8   CS#   INPUT   39.63m   1.44nH   0.12pF
H2   A10   INPUT   37.15m   1.36nH   0.11pF
H3   A1   INPUT   22.08m   0.76nH   0.08pF
H7   A2   INPUT   26.03m   0.85nH   0.09pF
H8   A0   INPUT   38.48m   1.43nH   0.12pF
H9   VDD   POWER   41.68m   1.20nH   0.22pF
J1   VSS   GND   12.32m   0.23nH   NA
J2   A3   INPUT   36.09m   1.30nH   0.11pF
J3   A5   INPUT   22.63m   0.71nH   0.08pF
J7   A6   INPUT   23.28m   0.74nH   0.08pF
J8   A4   INPUT   35.78m   1.30nH   0.11pF
K2   A7   INPUT   30.63m   1.12nH   0.10pF
K3   A9   INPUT   31.91m   0.72nH   0.09pF
K7   A11   INPUT   19.36m   0.63nH   0.08pF
K8   A8   INPUT   30.85m   1.15nH   0.10pF
K9   VSS   GND   20.12m   0.93nH   NA
L1   VDD   POWER   15.65m   0.71nH   0.22pF
L2   A12   INPUT   28.60m   1.05nH   0.10pF
L3   RFU   NC
L7   RFU   NC
L8   A13   INPUT   28.61m   1.06nH   0.10pF
|**********************DIFF PIN*********************************************
[Diff_pin]   inv_pin   vdiff   tdelay_typ   tdelay_min   tdelay_max
   E8   F8   .250V   0ns   NA   NA
   B7   A8   .250V   0ns   NA   NA
|  Pins B7 and A8 are a differential I/O only when DQS# is enabled via EMR
|  i.e EMR[E10]=0. If DQS# is disabled, then B7 (DQS) is a single ended I/O
|  and A8 is a NU
|   COMPONENT: MT47H256M4HQ_CLP (Common Landing Pattern)
[Component]  MT47H256M4HQ_CLP
[Manufacturer]  Micron Technology,Inc.
[Package]
|   typ   min   max
R_pkg   36.92m   19.36m   76.39m
L_pkg   1.31nH   0.63nH   2.77nH
C_pkg   0.11pF   0.08pF   0.18pF
[Pin]   signal_name model_name   R_pin   L_pin   C_pin
A1   NC   NC
A2   NC   NC
A8   NC   NC
A9   NC   NC
D1   NC   NC
D2   NC   NC
D3   NC   NC
D7   NC   NC
D8   NC   NC
D9   NC   NC
E1   NC   NC
E2   NC   NC
E3   NC   NC
E7   NC   NC
E8   NC   NC
E9   NC   NC
F1   NC   NC
F2   NC   NC
F3   NC   NC
F7   NC   NC
F8   NC   NC
F9   NC   NC
G1   NC   NC
G2   NC   NC
G3   NC   NC
G7   NC   NC
G8   NC   NC
G9   NC   NC
H1   VDD   POWER   28.06m   0.83nH   0.22pF
H2   NC   NF_INPUT   35.40m   1.33nH   0.10pF
H3   VSS   GND   10.78m   0.23nH   NA
H7   VSSQ   GND   17.01m   0.44nH   NA
H8   NU_DQS#   DQS#   45.34m   1.65nH   0.10pF
H9   VDDQ   POWER   1.04m   0.03nH   0.12pF
J1   NF   NF_INPUT   53.39m   1.95nH   0.14pF
J2   VSSQ   GND   3.15m   0.10nH   NA
J3   DM   DM   31.00m   0.84nH   0.11pF
J7   DQS   DQ   31.08m   1.05nH   0.12pF
J8   VSSQ   GND   43.72m   1.57nH   NA
J9   NF   NF_INPUT   70.83m   2.60nH   0.17pF
K1   VDDQ   POWER   27.86m   0.84nH   0.12pF
K2   DQ1   DQ   35.22m   1.30nH   0.11pF
K3   VDDQ   POWER   18.81m   0.66nH   0.12pF
K7   VDDQ   POWER   12.88m   0.29nH   0.12pF
K8   DQ0   DQ   70.15m   2.48nH   0.17pF
K9   VDDQ   POWER   25.92m   0.66nH   0.12pF
L1   NF   NF_INPUT   45.60m   1.76nH   0.13pF
L2   VSSQ   GND   21.17m   0.63nH   NA
L3   DQ3   DQ   31.46m   0.86nH   0.09pF
L7   DQ2   DQ   27.50m   0.80nH   0.09pF
L8   VSSQ   GND   21.17m   0.63nH   NA
L9   NF   NF_INPUT   76.39m   2.77nH   0.18pF
M1   VDDL   POWER   50.85m   1.96nH   0.14pF
M2   VREF   POWER   37.22m   1.41nH   0.12pF
M3   VSS   GND   2.34m   0.05nH   NA
M7   VSSDL   GND   28.52m   1.05nH   NA
M8   CK   CLKIN   41.35m   1.55nH   0.13pF
M9   VDD   POWER   7.49m   0.24nH   0.22pF
N2   CKE   INPUT   39.34m   1.48nH   0.12pF
N3   WE#   INPUT   24.58m   0.89nH   0.09pF
N7   RAS#   INPUT   25.78m   0.94nH   0.09pF
N8   CK#   CLKIN   42.93m   1.55nH   0.12pF
N9   ODT   INPUT   50.23m   1.92nH   0.14pF
P1   BA2   INPUT   49.69m   1.87nH   0.14pF
P2   BA0   INPUT   39.93m   1.48nH   0.12pF
P3   BA1   INPUT   25.65m   0.89nH   0.09pF
P7   CAS#   INPUT   22.15m   0.79nH   0.09pF
P8   CS#   INPUT   39.63m   1.44nH   0.12pF
R2   A10   INPUT   37.15m   1.36nH   0.11pF
R3   A1   INPUT   22.08m   0.76nH   0.08pF
R7   A2   INPUT   26.03m   0.85nH   0.09pF
R8   A0   INPUT   38.48m   1.43nH   0.12pF
R9   VDD   POWER   41.68m   1.20nH   0.22pF
T1   VSS   GND   12.32m   0.23nH   NA
T2   A3   INPUT   36.09m   1.30nH   0.11pF
T3   A5   INPUT   22.63m   0.71nH   0.08pF
T7   A6   INPUT   23.28m   0.74nH   0.08pF
T8   A4   INPUT   35.78m   1.30nH   0.11pF
U2   A7   INPUT   30.63m   1.12nH   0.10pF
U3   A9   INPUT   31.91m   0.72nH   0.09pF
U7   A11   INPUT   19.36m   0.63nH   0.08pF
U8   A8   INPUT   30.85m   1.15nH   0.10pF
U9   VSS   GND   20.12m   0.93nH   NA
V1   VDD   POWER   15.65m   0.71nH   0.22pF
V2   A12   INPUT   28.60m   1.05nH   0.10pF
V3   RFU   NC
V7   RFU   NC
V8   A13   INPUT   28.61m   1.06nH   0.10pF
AA1   NC   NC
AA2   NC   NC
AA8   NC   NC
AA9   NC   NC
AB1   NC   NC
AB2   NC   NC
AB8   NC   NC
AB9   NC   NC
|**********************DIFF PIN*********************************************
[Diff_pin]   inv_pin   vdiff   tdelay_typ   tdelay_min   tdelay_max
   M8   N8   .250V   0ns   NA   NA
   J7   H8   .250V   0ns   NA   NA
|  Pins J7 and H8 are a differential I/O only when DQS# is enabled via EMR
|  i.e EMR[E10]=0. If DQS# is disabled, then J7 (DQS) is a single ended I/O
|  and H8 is a NU
|   COMPONENT: MT47H128M8HQ (60-Ball FBGA, x8)
[Component]   MT47H128M8HQ
[Manufacturer]  Micron Technology,Inc.
[Package]
|   typ   min   max
R_pkg   36.92m   19.36m   76.39m
L_pkg   1.31nH   0.63nH   2.77nH
C_pkg   0.11pF   0.08pF   0.18pF
[Pin]   signal_name model_name   R_pin   L_pin   C_pin
A1   VDD   POWER   28.06m   0.83nH   0.22pF
A2   NU_RDQS#   RDQS#   35.40m   1.33nH   0.10pF
A3   VSS   GND   10.78m   0.23nH   NA
A7   VSSQ   GND   17.01m   0.44nH   NA
A8   NU_DQS#   DQS#   45.34m   1.65nH   0.10pF
A9   VDDQ   POWER   1.04m   0.03nH   0.12pF
B1   DQ6   DQ   53.39m   1.95nH   0.14pF
B2   VSSQ   GND   3.15m   0.10nH   NA
B3   DM_RDQS   DM_RDQS   31.00m   0.84nH   0.11pF
B7   DQS   DQ   31.08m   1.05nH   0.12pF
B8   VSSQ   GND   43.72m   1.57nH   NA
B9   DQ7   DQ   70.83m   2.60nH   0.17pF
C1   VDDQ   POWER   27.86m   0.84nH   0.12pF
C2   DQ1   DQ   35.22m   1.30nH   0.11pF
C3   VDDQ   POWER   18.81m   0.66nH   0.12pF
C7   VDDQ   POWER   12.88m   0.29nH   0.12pF
C8   DQ0   DQ   70.15m   2.48nH   0.17pF
C9   VDDQ   POWER   25.92m   0.66nH   0.12pF
D1   DQ4   DQ   45.60m   1.76nH   0.13pF
D2   VSSQ   GND   21.17m   0.63nH   NA
D3   DQ3   DQ   31.46m   0.86nH   0.09pF
D7   DQ2   DQ   27.50m   0.80nH   0.09pF
D8   VSSQ   GND   21.17m   0.63nH   NA
D9   DQ5   DQ   76.39m   2.77nH   0.18pF
E1   VDDL   POWER   50.85m   1.96nH   0.14pF
E2   VREF   POWER   37.22m   1.41nH   0.12pF
E3   VSS   GND   2.34m   0.05nH   NA
E7   VSSDL   GND   28.52m   1.05nH   NA
E8   CK   CLKIN   41.35m   1.55nH   0.13pF
E9   VDD   POWER   7.49m   0.24nH   0.22pF
F2   CKE   INPUT   39.34m   1.48nH   0.12pF
F3   WE#   INPUT   24.58m   0.89nH   0.09pF
F7   RAS#   INPUT   25.78m   0.94nH   0.09pF
F8   CK#   CLKIN   42.93m   1.55nH   0.12pF
F9   ODT   INPUT   50.23m   1.92nH   0.14pF
G1   BA2   INPUT   49.69m   1.87nH   0.14pF
G2   BA0   INPUT   39.93m   1.48nH   0.12pF
G3   BA1   INPUT   25.65m   0.89nH   0.09pF
G7   CAS#   INPUT   22.15m   0.79nH   0.09pF
G8   CS#   INPUT   39.63m   1.44nH   0.12pF
H2   A10   INPUT   37.15m   1.36nH   0.11pF
H3   A1   INPUT   22.08m   0.76nH   0.08pF
H7   A2   INPUT   26.03m   0.85nH   0.09pF
H8   A0   INPUT   38.48m   1.43nH   0.12pF
H9   VDD   POWER   41.68m   1.20nH   0.22pF
J1   VSS   GND   12.32m   0.23nH   NA
J2   A3   INPUT   36.09m   1.30nH   0.11pF
J3   A5   INPUT   22.63m   0.71nH   0.08pF
J7   A6   INPUT   23.28m   0.74nH   0.08pF
J8   A4   INPUT   35.78m   1.30nH   0.11pF
K2   A7   INPUT   30.63m   1.12nH   0.10pF
K3   A9   INPUT   31.91m   0.72nH   0.09pF
K7   A11   INPUT   19.36m   0.63nH   0.08pF
K8   A8   INPUT   30.85m   1.15nH   0.10pF
K9   VSS   GND   20.12m   0.93nH   NA
L1   VDD   POWER   15.65m   0.71nH   0.22pF
L2   A12   INPUT   28.60m   1.05nH   0.10pF
L3   RFU   NC
L7   RFU   NC
L8   A13   INPUT   28.61m   1.06nH   0.10pF
|**********************DIFF PIN*********************************************
[Diff_pin]   inv_pin   vdiff   tdelay_typ   tdelay_min   tdelay_max
   E8   F8   .250V   0ns   NA   NA
   B7   A8   .250V   0ns   NA   NA
   B3   A2   .250V   0ns   NA   NA
|  Pins B7 and A8 are a differential I/O only when DQS# is enabled via EMR
|  i.e EMR[E10]=0. If DQS# is disabled, then B7 (DQS) is a single ended I/O
|  and A8 is a NU
|  Pins B3 and A2 (RDQS, RDQS#) are differential output when RDQS enabled via
|  EMR command bit E11=0 and RDQS# is enabled via both EMR setting (E10=0,
|  DQS#enable and E11=1, RDQS enabled). When RDQS disbaled it becomes DM and
| when RDQS# disabled it becomes NU.
|   COMPONENT: MT47H128M8HQ_CLP (Common Landing Pattern)
[Component]  MT47H128M8HQ_CLP
[Manufacturer]  Micron Technology,Inc.
[Package]
|   typ   min   max
R_pkg   36.92m   19.36m   76.39m
L_pkg   1.31nH   0.63nH   2.77nH
C_pkg   0.11pF   0.08pF   0.18pF
[Pin]   signal_name model_name   R_pin   L_pin   C_pin
A1   NC   NC
A2   NC   NC
A8   NC   NC
A9   NC   NC
D1   NC   NC
D2   NC   NC
D3   NC   NC
D7   NC   NC
D8   NC   NC
D9   NC   NC
E1   NC   NC
E2   NC   NC
E3   NC   NC
E7   NC   NC
E8   NC   NC
E9   NC   NC
F1   NC   NC
F2   NC   NC
F3   NC   NC
F7   NC   NC
F8   NC   NC
F9   NC   NC
G1   NC   NC
G2   NC   NC
G3   NC   NC
G7   NC   NC
G8   NC   NC
G9   NC   NC
H1   VDD   POWER   28.06m   0.83nH   0.22pF
H2   NU_RDQS#   RDQS#   35.40m   1.33nH   0.10pF
H3   VSS   GND   10.78m   0.23nH   NA
H7   VSSQ   GND   17.01m   0.44nH   NA
H8   NU_DQS#   DQS#   45.34m   1.65nH   0.10pF
H9   VDDQ   POWER   1.04m   0.03nH   0.12pF
J1   DQ6   DQ   53.39m   1.95nH   0.14pF
J2   VSSQ   GND   3.15m   0.10nH   NA
J3   DM_RDQS   DM_RDQS   31.00m   0.84nH   0.11pF
J7   DQS   DQ   31.08m   1.05nH   0.12pF
J8   VSSQ   GND   43.72m   1.57nH   NA
J9   DQ7   DQ   70.83m   2.60nH   0.17pF
K1   VDDQ   POWER   27.86m   0.84nH   0.12pF
K2   DQ1   DQ   35.22m   1.30nH   0.11pF
K3   VDDQ   POWER   18.81m   0.66nH   0.12pF
K7   VDDQ   POWER   12.88m   0.29nH   0.12pF
K8   DQ0   DQ   70.15m   2.48nH   0.17pF
K9   VDDQ   POWER   25.92m   0.66nH   0.12pF
L1   DQ4   DQ   45.60m   1.76nH   0.13pF
L2   VSSQ   GND   21.17m   0.63nH   NA
L3   DQ3   DQ   31.46m   0.86nH   0.09pF
L7   DQ2   DQ   27.50m   0.80nH   0.09pF
L8   VSSQ   GND   21.17m   0.63nH   NA
L9   DQ5   DQ   76.39m   2.77nH   0.18pF
M1   VDDL   POWER   50.85m   1.96nH   0.14pF
M2   VREF   POWER   37.22m   1.41nH   0.12pF
M3   VSS   GND   2.34m   0.05nH   NA
M7   VSSDL   GND   28.52m   1.05nH   NA
M8   CK   CLKIN   41.35m   1.55nH   0.13pF
M9   VDD   POWER   7.49m   0.24nH   0.22pF
N2   CKE   INPUT   39.34m   1.48nH   0.12pF
N3   WE#   INPUT   24.58m   0.89nH   0.09pF
N7   RAS#   INPUT   25.78m   0.94nH   0.09pF
N8   CK#   CLKIN   42.93m   1.55nH   0.12pF
N9   ODT   INPUT   50.23m   1.92nH   0.14pF
P1   BA2   INPUT   49.69m   1.87nH   0.14pF
P2   BA0   INPUT   39.93m   1.48nH   0.12pF
P3   BA1   INPUT   25.65m   0.89nH   0.09pF
P7   CAS#   INPUT   22.15m   0.79nH   0.09pF
P8   CS#   INPUT   39.63m   1.44nH   0.12pF
R2   A10   INPUT   37.15m   1.36nH   0.11pF
R3   A1   INPUT   22.08m   0.76nH   0.08pF
R7   A2   INPUT   26.03m   0.85nH   0.09pF
R8   A0   INPUT   38.48m   1.43nH   0.12pF
R9   VDD   POWER   41.68m   1.20nH   0.22pF
T1   VSS   GND   12.32m   0.23nH   NA
T2   A3   INPUT   36.09m   1.30nH   0.11pF
T3   A5   INPUT   22.63m   0.71nH   0.08pF
T7   A6   INPUT   23.28m   0.74nH   0.08pF
T8   A4   INPUT   35.78m   1.30nH   0.11pF
U2   A7   INPUT   30.63m   1.12nH   0.10pF
U3   A9   INPUT   31.91m   0.72nH   0.09pF
U7   A11   INPUT   19.36m   0.63nH   0.08pF
U8   A8   INPUT   30.85m   1.15nH   0.10pF
U9   VSS   GND   20.12m   0.93nH   NA
V1   VDD   POWER   15.65m   0.71nH   0.22pF
V2   A12   INPUT   28.60m   1.05nH   0.10pF
V3   RFU   NC
V7   RFU   NC
V8   A13   INPUT   28.61m   1.06nH   0.10pF
AA1   NC   NC
AA2   NC   NC
AA8   NC   NC
AA9   NC   NC
AB1   NC   NC
AB2   NC   NC
AB8   NC   NC
AB9   NC   NC
|**********************DIFF PIN*********************************************
[Diff_pin]   inv_pin   vdiff   tdelay_typ   tdelay_min   tdelay_max
   M8   N8   .250V   0ns   NA   NA
   J7   H8   .250V   0ns   NA   NA
   J3   H2   .250V   0ns   NA   NA
|  Pins J7 and H8 are a differential I/O only when DQS# is enabled via EMR
|  i.e EMR[E10]=0. If DQS# is disabled, then J7 (DQS) is a single ended I/O
|  and H8 is a NU
|  Pins J3 and H2 (RDQS, RDQS#) are differential output when RDQS enabled via
|  EMR command bit E11=0 and RDQS# is enabled via both EMR setting (E10=0,
|  DQS#enable and E11=1, RDQS enabled). When RDQS disbaled it becomes DM and
| when RDQS# disabled it becomes NU.
|   Model Selector
[Model Selector] RDQS#
NF_INPUT   Not Used if either RDQS or Diff. Strobe are disabled
RDQS_FULL_533   Full-Drv Output Drvr with no ODT (400/533 Mbps)
RDQS_HALF_533   Reduced-Drv Output Drvr with no ODT (400/533Mbps)
RDQS_FULL_667   Full-Drv Output Drvr with no ODT (667 Mbps)
RDQS_HALF_667   Reduced-Drv Output Drvr with no ODT (667 Mbps)
RDQS_FULL_1066  Full-Drv Output Drvr with no ODT (800/1066 Mbps)
RDQS_HALF_1066  Reduced-Drv Output Drvr with no ODT (800/1066 Mbps)
[Model Selector] DM_RDQS
DM_INPUT_533   DM input model with no ODT (400/533 Mbps)
DM_ODT50_533   DM Input model with 50 Ohm ODT Submodel (400/533 Mbps)
DM_ODT75_533   DM Input model with 75 Ohm ODT Submodel(400/533 Mbps)
DM_ODT150_533   DM Input model with 150 Ohm ODT Submodel (400/533 Mbps)
RDQS_FULL_533   Full-Drv Output Drvr if RDQS is enabled (400/533 Mbps)
RDQS_HALF_533   Reduced-Drv Output Drvr if RDQS is enabled (400/533 Mbps)
DM_INPUT_667   DM input model with no ODT (667 Mbps)
DM_ODT50_667   DM Input model with 50 Ohm ODT Submodel (667 Mbps)
DM_ODT75_667   DM Input model with 75 Ohm ODT Submodel(667 Mbps)
DM_ODT150_667   DM Input model with 150 Ohm ODT Submodel (667 Mbps)
RDQS_FULL_667   Full-Drv Output Drvr if RDQS is enabled (667 Mbps)
RDQS_HALF_667   Reduced-Drv Output Drvr if RDQS is enabled (667 Mbps)
DM_INPUT_1066   DM input model with no ODT (800/1066 Mbps)
DM_ODT50_1066   DM Input model with 50 Ohm ODT Submodel (800/1066 Mbps)
DM_ODT75_1066   DM Input model with 75 Ohm ODT Submodel (800/1066 Mbps)
DM_ODT150_1066  DM Input model with 150 Ohm ODT Submodel (800/1066 Mbps)
RDQS_FULL_1066  Full-Drv Output Drvr if RDQS is enabled (800/1066 Mbps)
RDQS_HALF_1066  Reduced-Drv Output Drvr if RDQS is enabled (800/1066 Mbps)
|   COMPONENT: MT47H64M16HR (84-Ball FBGA, x16)
[Component]   MT47H64M16HR
[Manufacturer]  Micron Technology,Inc.
[Package]
|   typ   min   max
R_pkg   43.97m   29.91m   65.39m
L_pkg   1.31nH   0.74nH   2.28nH
C_pkg   0.12pF   0.09pF   0.15pF
[Pin]   signal_name model_name   R_pin   L_pin   C_pin
A1   VDD   POWER   16.51m   0.50nH   0.17pF
A2   NC   NC
A3   VSS   GND   1.86m   0.04nH   NA
A7   VSSQ   GND   11.79m   0.27nH   NA
A8   UDQS#_NU   DQS#   58.07m   1.60nH   0.10pF
A9   VDDQ   POWER   29.81m   0.90nH   0.11pF
B1   DQ14   DQ   52.06m   1.87nH   0.14pF
B2   VSSQ   GND   14.60m   0.41nH   NA
B3   UDM   DM   48.04m   1.01nH   0.10pF
B7   UDQS   DQ   60.33m   1.19nH   0.12pF
B8   VSSQ   GND   31.46m   1.20nH   NA
B9   DQ15   DQ   65.39m   2.28nH   0.15pF
C1   VDDQ   POWER   30.05m   0.92nH   0.11pF
C2   DQ9   DQ   50.23m   1.39nH   0.12pF
C3   VDDQ   POWER   4.77m   0.08nH   0.11pF
C7   VDDQ   POWER   8.81m   0.27nH   0.11pF
C8   DQ8   DQ   54.93m   2.02nH   0.15pF
C9   VDDQ   POWER   22.79m   0.55nH   0.11pF
D1   DQ12   DQ   49.15m   1.72nH   0.14pF
D2   VSSQ   GND   16.99m   0.50nH   NA
D3   DQ11   DQ   50.87m   0.95nH   0.10pF
D7   DQ10   DQ   50.27m   0.95nH   0.10pF
D8   VSSQ   GND   17.02m   0.42nH   NA
D9   DQ13   DQ   50.45m   1.79nH   0.14pF
E1   VDD   POWER   22.43m   0.66nH   0.17pF
E2   NC   NC
E3   VSS   GND   14.43m   0.50nH   NA
E7   VSSQ   GND   6.23m   0.14nH   NA
E8   LDQS#_NU   DQS#   54.07m   1.46nH   0.09pF
E9   VDDQ   POWER   28.50m   0.90nH   0.11pF
F1   DQ6   DQ   51.22m   1.91nH   0.15pF
F2   VSSQ   GND   16.25m   0.43nH   NA
F3   LDM   DM   47.60m   0.96nH   0.10pF
F7   LDQS   DQ   45.09m   0.83nH   0.12pF
F8   VSSQ   GND   15.66m   0.46nH   NA
F9   DQ7   DQ   51.62m   1.97nH   0.14pF
G1   VDDQ   POWER   61.97m   2.35nH   0.11pF
G2   DQ1   DQ   51.20m   1.48nH   0.13pF
G3   VDDQ   POWER   7.88m   0.20nH   0.11pF
G7   VDDQ   POWER   8.83m   0.24nH   0.11pF
G8   DQ0   DQ   55.06m   2.05nH   0.14pF
G9   VDDQ   POWER   44.87m   1.43nH   0.11pF
H1   DQ4   DQ   52.81m   2.04nH   0.15pF
H2   VSSQ   GND   18.81m   0.58nH   NA
H3   DQ3   DQ   48.56m   1.11nH   0.11pF
H7   DQ2   DQ   47.60m   1.07nH   0.11pF
H8   VSSQ   GND   18.66m   0.50nH   NA
H9   DQ5   DQ   50.56m   1.78nH   0.14pF
J1   VDDL   POWER   48.39m   1.75nH   0.14pF
J2   VREF   POWER   32.36m   1.14nH   0.11pF
J3   VSS   GND   1.53m   0.04nH   NA
J7   VSSDL   GND   14.95m   0.52nH   NA
J8   CK   CLKIN   30.00m   1.12nH   0.11pF
J9   VDD   POWER   2.00m   0.05nH   0.17pF
K2   CKE   INPUT   37.22m   1.25nH   0.11pF
K3   WE#   INPUT   37.11m   0.76nH   0.09pF
K7   RAS#   INPUT   35.87m   0.77nH   0.09pF
K8   CK#   CLKIN   29.91m   1.11nH   0.11pF
K9   ODT   INPUT   48.52m   1.73nH   0.14pF
L1   BA2   INPUT   39.42m   1.58nH   0.12pF
L2   BA0   INPUT   37.23m   1.20nH   0.11pF
L3   BA1   INPUT   35.77m   0.74nH   0.09pF
L7   CAS   INPUT   36.10m   0.78nH   0.09pF
L8   CS#   INPUT   37.79m   1.20nH   0.11pF
M2   A10   INPUT   35.79m   1.15nH   0.11pF
M3   A1   INPUT   35.63m   0.79nH   0.09pF
M7   A2   INPUT   34.70m   0.75nH   0.09pF
M8   A0   INPUT   34.39m   1.17nH   0.11pF
M9   VDD   POWER   52.48m   1.87nH   0.17pF
N1   VSS   GND   32.35m   1.11nH   NA
N2   A3   INPUT   34.40m   1.19nH   0.11pF
N3   A5   INPUT   38.17m   0.95nH   0.10pF
N7   A6   INPUT   36.69m   0.92nH   0.10pF
N8   A4   INPUT   35.66m   1.20nH   0.11pF
P2   A7   INPUT   36.76m   1.40nH   0.12pF
P3   A9   INPUT   36.49m   1.06nH   0.10pF
P7   A11   INPUT   35.80m   1.05nH   0.10pF
P8   A8   INPUT   37.19m   1.42nH   0.12pF
P9   VSS   GND   20.54m   0.63nH   NA
R1   VDD   POWER   7.53m   0.22nH   0.17pF
R2   A12   INPUT   40.66m   1.60nH   0.13pF
R3   RFU   NC
R7   RFU   NC
R8   RFU   NC
|**********************DIFF PIN*********************************************
[Diff_pin]   inv_pin   vdiff   tdelay_typ   tdelay_min   tdelay_max
   B7   A8   .250V   0ns   NA   NA
   F7   E8   .250V   0ns   NA   NA
   J8   K8   .250V   0ns   NA   NA
|  Pins B7 and A8 are a differential I/O only when UDQS# is enabled via EMR
|  If UDQS# is disabled, then B7 (UDQS) is a single ended I/O and A8 is a NU
|  Pins F7 and E8 are a differential I/O only when LDQS# is enabled via EMR
|  If LDQS# is disabled, then E8 (LDQS) is a single ended I/O and F7 is a NU
|   COMPONENT: MT47H64M16HR_CLP (Common Landing Pattern)
[Component]  MT47H64M16HR_CLP
[Manufacturer]  Micron Technology,Inc.
[Package]
|   typ   min   max
R_pkg   43.97m   29.91m   65.39m
L_pkg   1.31nH   0.74nH   2.28nH
C_pkg   0.12pF   0.09pF   0.15pF
[Pin]   signal_name model_name   R_pin   L_pin   C_pin
A1   NC   NC
A2   NC   NC
A8   NC   NC
A9   NC   NC
D1   VDD   POWER   16.51m   0.50nH   0.17pF
D2   NC   NC
D3   VSS   GND   1.86m   0.04nH   NA
D7   VSSQ   GND   11.79m   0.27nH   NA
D8   UDQS#_NU   DQS#   58.07m   1.60nH   0.10pF
D9   VDDQ   POWER   29.81m   0.90nH   0.11pF
E1   DQ14   DQ   52.06m   1.87nH   0.14pF
E2   VSSQ   GND   14.60m   0.41nH   NA
E3   UDM   DM   48.04m   1.01nH   0.10pF
E7   UDQS   DQ   60.33m   1.19nH   0.12pF
E8   VSSQ   GND   31.46m   1.20nH   NA
E9   DQ15   DQ   65.39m   2.28nH   0.15pF
F1   VDDQ   POWER   30.05m   0.92nH   0.11pF
F2   DQ9   DQ   50.23m   1.39nH   0.12pF
F3   VDDQ   POWER   4.77m   0.08nH   0.11pF
F7   VDDQ   POWER   8.81m   0.27nH   0.11pF
F8   DQ8   DQ   54.93m   2.02nH   0.15pF
F9   VDDQ   POWER   22.79m   0.55nH   0.11pF
G1   DQ12   DQ   49.15m   1.72nH   0.14pF
G2   VSSQ   GND   16.99m   0.50nH   NA
G3   DQ11   DQ   50.87m   0.95nH   0.10pF
G7   DQ10   DQ   50.27m   0.95nH   0.10pF
G8   VSSQ   GND   17.02m   0.42nH   NA
G9   DQ13   DQ   50.45m   1.79nH   0.14pF
H1   VDD   POWER   22.43m   0.66nH   0.17pF
H2   NC   NC
H3   VSS   GND   14.43m   0.50nH   NA
H7   VSSQ   GND   6.23m   0.14nH   NA
H8   LDQS#_NU   DQS#   54.07m   1.46nH   0.09pF
H9   VDDQ   POWER   28.50m   0.90nH   0.11pF
J1   DQ6   DQ   51.22m   1.91nH   0.15pF
J2   VSSQ   GND   16.25m   0.43nH   NA
J3   LDM   DM   47.60m   0.96nH   0.10pF
J7   LDQS   DQ   45.09m   0.83nH   0.12pF
J8   VSSQ   GND   15.66m   0.46nH   NA
J9   DQ7   DQ   51.62m   1.97nH   0.14pF
K1   VDDQ   POWER   61.97m   2.35nH   0.11pF
K2   DQ1   DQ   51.20m   1.48nH   0.13pF
K3   VDDQ   POWER   7.88m   0.20nH   0.11pF
K7   VDDQ   POWER   8.83m   0.24nH   0.11pF
K8   DQ0   DQ   55.06m   2.05nH   0.14pF
K9   VDDQ   POWER   44.87m   1.43nH   0.11pF
L1   DQ4   DQ   52.81m   2.04nH   0.15pF
L2   VSSQ   GND   18.81m   0.58nH   NA
L3   DQ3   DQ   48.56m   1.11nH   0.11pF
L7   DQ2   DQ   47.60m   1.07nH   0.11pF
L8   VSSQ   GND   18.66m   0.50nH   NA
L9   DQ5   DQ   50.56m   1.78nH   0.14pF
M1   VDDL   POWER   48.39m   1.75nH   0.14pF
M2   VREF   POWER   32.36m   1.14nH   0.11pF
M3   VSS   GND   1.53m   0.04nH   NA
M7   VSSDL   GND   14.95m   0.52nH   NA
M8   CK   CLKIN   30.00m   1.12nH   0.11pF
M9   VDD   POWER   2.00m   0.05nH   0.17pF
N2   CKE   INPUT   37.22m   1.25nH   0.11pF
N3   WE#   INPUT   37.11m   0.76nH   0.09pF
N7   RAS#   INPUT   35.87m   0.77nH   0.09pF
N8   CK#   CLKIN   29.91m   1.11nH   0.11pF
N9   ODT   INPUT   48.52m   1.73nH   0.14pF
P1   BA2   INPUT   39.42m   1.58nH   0.12pF
P2   BA0   INPUT   37.23m   1.20nH   0.11pF
P3   BA1   INPUT   35.77m   0.74nH   0.09pF
P7   CAS#   INPUT   36.10m   0.78nH   0.09pF
P8   CS#   INPUT   37.79m   1.20nH   0.11pF
R2   A10   INPUT   35.79m   1.15nH   0.11pF
R3   A1   INPUT   35.63m   0.79nH   0.09pF
R7   A2   INPUT   34.70m   0.75nH   0.09pF
R8   A0   INPUT   34.39m   1.17nH   0.11pF
R9   VDD   POWER   52.48m   1.87nH   0.17pF
T1   VSS   GND   32.35m   1.11nH   NA
T2   A3   INPUT   34.40m   1.19nH   0.11pF
T3   A5   INPUT   38.17m   0.95nH   0.10pF
T7   A6   INPUT   36.69m   0.92nH   0.10pF
T8   A4   INPUT   35.66m   1.20nH   0.11pF
U2   A7   INPUT   36.76m   1.40nH   0.12pF
U3   A9   INPUT   36.49m   1.06nH   0.10pF
U7   A11   INPUT   35.80m   1.05nH   0.10pF
U8   A8   INPUT   37.19m   1.42nH   0.12pF
U9   VSS   GND   20.54m   0.63nH   NA
V1   VDD   POWER   7.53m   0.22nH   0.17pF
V2   A12   INPUT   40.66m   1.60nH   0.13pF
V3   A14   NC
V7   A15   NC
V8   A13   NC
AA1   NC   NC
AA2   NC   NC
AA8   NC   NC
AA9   NC   NC
AB1   NC   NC
AB2   NC   NC
AB8   NC   NC
AB9   NC   NC
|**********************DIFF PIN*********************************************
[Diff_pin]   inv_pin   vdiff   tdelay_typ   tdelay_min   tdelay_max
   M8   N8   .250V   0ns   NA   NA
   J7   H8   .250V   0ns   NA   NA
   E7   D8   .250V   0ns   NA   NA
|  Pins J7 and H8 are a differential I/O only when LDQS# is enabled via EMR
|  If LDQS# is disabled, then J7 (LDQS) is a single ended I/O and H8 is a NU
|  Pins E7 and D8 are a differential I/O only when UDQS# is enabled via EMR
|  If UDQS# is disabled, then E7 (UDQS) is a single ended I/O and D8 is a NU
|   Model Selector
[Model Selector] DM
DM_INPUT_533   DM input model with no ODT (400/533 Mbps)
DM_ODT50_533   DM Input model with 50 Ohm ODT Submodel (400/533 Mbps)
DM_ODT75_533   DM Input model with 75 Ohm ODT Submodel (400/533 Mbps)
DM_ODT150_533   DM Input model with 150 Ohm ODT Submodel (400/533Mbps)
DM_INPUT_667   DM input model with no ODT (667 Mbps)
DM_ODT50_667   DM Input model with 50 Ohm ODT Submodel (667 Mbps)
DM_ODT75_667   DM Input model with 75 Ohm ODT Submodel (667 Mbps)
DM_ODT150_667   DM Input model with 150 Ohm ODT Submodel (667 Mbps)
DM_INPUT_1066   DM input model with no ODT (800/1066 Mbps)
DM_ODT50_1066   DM Input model with 50 Ohm ODT Submodel (800/1066 Mbps)
DM_ODT75_1066   DM Input model with 75 Ohm ODT Submodel (800/1066 Mbps)
DM_ODT150_1066   DM Input model with 150 Ohm ODT Submodel (800/1066 Mbps)
[Model Selector] DQ
DQFULL_533   Full-Drv IO Drvr with no ODT (400/533 Mbps)
DQFULL_ODT50_533   Full-Drv IO Drvr with 50 Ohm ODT Submodel (400/533 Mbps)
DQFULL_ODT75_533   Full-Drv IO Drvr with 75 Ohm ODT Submodel (400/533 Mbps)
DQFULL_ODT150_533  Full-Drv IO Drvr with 150 Ohm ODT Submodel(400/533 Mbps)
DQHALF_533   Reduced-Drv IO Drvr with no ODT (400/533 Mbps)
DQHALF_ODT50_533   Reduced-Drv IO Drvr with 50 Ohm ODT Submodel (400/533 Mbps)
DQHALF_ODT75_533   Reduced-Drv IO Drvr with 75 Ohm ODT Submodel (400/533 Mbps)
DQHALF_ODT150_533  Reduced-Drv IO Drvr with 150 Ohm ODT Submodel (400/533 Mbps)
DQFULL_667   Full-Drv IO Drvr with no ODT (667 Mbps)
DQFULL_ODT50_667   Full-Drv IO Drvr with 50 Ohm ODT Submodel (667 Mbps)
DQFULL_ODT75_667   Full-Drv IO Drvr with 75 Ohm ODT Submodel (667 Mbps)
DQFULL_ODT150_667  Full-Drv IO Drvr with 150 Ohm ODT Submodel (667 Mbps)
DQHALF_667   Reduced-Drv IO Drvr with no ODT(667 Mbps)
DQHALF_ODT50_667   Reduced-Drv IO Drvr with 50 Ohm ODT Submodel (667 Mbps)
DQHALF_ODT75_667   Reduced-Drv IO Drvr with 75 Ohm ODT Submodel (667 Mbps)
DQHALF_ODT150_667  Reduced-Drv IO Drvr with 150 Ohm ODT Submodel (667 Mbps)
DQFULL_1066   Full-Drv IO Drvr with no ODT (800/1066 Mbps)
DQFULL_ODT50_1066  Full-Drv IO Drvr with 50 Ohm ODT Submodel (800/1066 Mbps)
DQFULL_ODT75_1066  Full-Drv IO Drvr with 75 Ohm ODT Submodel (800/1066 Mbps)
DQFULL_ODT150_1066 Full-Drv IO Drvr with 150 Ohm ODT Submodel (800/1066 Mbps)
DQHALF_1066   Reduced-Drv IO Drvr with no ODT (800/1066 Mbps)
DQHALF_ODT50_1066  Reduced-Drv IO Drvr with 50 Ohm ODT Submodel (800/1066 Mbps)
DQHALF_ODT75_1066  Reduced-Drv IO Drvr with 75 Ohm ODT Submodel (800/1066 Mbps)
DQHALF_ODT150_1066 Reduced-Drv IO Drvr with 150 Ohm ODT Submodel (800/1066 Mbps)
[Model Selector] DQS#
DQFULL_533   Full-Drv IO Drvr with no ODT (400/533 Mbps)
DQFULL_ODT50_533   Full-Drv IO Drvr with 50 Ohm ODT Submodel (400/533 Mbps)
DQFULL_ODT75_533   Full-Drv IO Drvr with 75 Ohm ODT Submodel (400/533 Mbps)
DQFULL_ODT150_533  Full-Drv IO Drvr with 150 Ohm ODT Submodel (400/533Mbps)
DQHALF_533   Reduced-Drv IO Drvr with no ODT (400/533 Mbps)
DQHALF_ODT50_533   Reduced-Drv IO Drvr with 50 Ohm ODT Submodel (400/533 Mbps)
DQHALF_ODT75_533   Reduced-Drv IO Drvr with 75 Ohm ODT Submodel (400/533 Mbps)
DQHALF_ODT150_533  Reduced-Drv IO Drvr with 150 Ohm ODT Submodel (400/533 Mbps)
DQFULL_667   Full-Drv IO Drvr with no ODT (667 Mbps)
DQFULL_ODT50_667   Full-Drv IO Drvr with 50 Ohm ODT Submodel (667 Mbps)
DQFULL_ODT75_667   Full-Drv IO Drvr with 75 Ohm ODT Submodel (667 Mbps)
DQFULL_ODT150_667  Full-Drv IO Drvr with 150 Ohm ODT Submodel (667 Mbps)
DQHALF_667   Reduced-Drv IO Drvr with no ODT (667 Mbps)
DQHALF_ODT50_667   Reduced-Drv IO Drvr with 50 Ohm ODT Submodel (667 Mbps)
DQHALF_ODT75_667   Reduced-Drv IO Drvr with 75 Ohm ODT Submodel (667 Mbps)
DQHALF_ODT150_667  Reduced-Drv IO Drvr with 150 Ohm ODT Submodel (667 Mbps)
DQFULL_1066   Full-Drv IO Drvr with no ODT (800/1066 Mbps)
DQFULL_ODT50_1066  Full-Drv IO Drvr with 50 Ohm ODT Submodel (800/1066 Mbps)
DQFULL_ODT75_1066  Full-Drv IO Drvr with 75 Ohm ODT Submodel (800/1066 Mbps)
DQFULL_ODT150_1066 Full-Drv IO Drvr with 150 Ohm ODT Submodel (800/1066 Mbps)
DQHALF_1066   Reduced-Drv IO Drvr with no ODT (800/1066 Mbps)
DQHALF_ODT50_1066  Reduced-Drv IO Drvr with 50 Ohm ODT Submodel (800/1066 Mbps)
DQHALF_ODT75_1066  Reduced-Drv IO Drvr with 75 Ohm ODT Submodel (800/1066 Mbps)
DQHALF_ODT150_1066 Reduced-Drv IO Drvr with 150 Ohm ODT Submodel(800/1066 Mbps)
NF_INPUT   (Use to disable DQS#)
[Model Selector] INPUT
INPUT_533   Input Model for 400/533 Speed Grade
INPUT_667   Input Model for 667 Speed Grade
INPUT_1066   Input Model for 800/1066 Speed Grade
[Model Selector] CLKIN
CLKIN_533   Clock Input Model for 400/533 Speed Grade
CLKIN_667   Clock Input Model for 667 Speed Grade
CLKIN_1066   Clock Input Model for 800/1066 Speed Grade
| Models and submodels in the file (58): DQFULL_533 (I/O), DQFULL_ODT50_533 (I/O), DQFULL_ODT75_533 (I/O), DQFULL_ODT150_533 (I/O), DQHALF_533 (I/O), DQHALF_ODT50_533 (I/O), DQHALF_ODT75_533 (I/O), DQHALF_ODT150_533 (I/O), DQFULL_667 (I/O), DQFULL_ODT50_667 (I/O), DQFULL_ODT75_667 (I/O), DQFULL_ODT150_667 (I/O), DQHALF_667 (I/O), DQHALF_ODT50_667 (I/O), DQHALF_ODT75_667 (I/O), DQHALF_ODT150_667 (I/O), DQFULL_1066 (I/O), DQFULL_ODT50_1066 (I/O), DQFULL_ODT75_1066 (I/O), DQFULL_ODT150_1066 (I/O), DQHALF_1066 (I/O), DQHALF_ODT50_1066 (I/O), DQHALF_ODT75_1066 (I/O), DQHALF_ODT150_1066 (I/O), RDQS_FULL_533 (Output), RDQS_HALF_533 (Output), RDQS_FULL_667 (Output), RDQS_HALF_667 (Output), RDQS_FULL_1066 (Output), RDQS_HALF_1066 (Output), DM_INPUT_533 (Input), DM_ODT50_533 (Input), DM_ODT75_533 (Input), DM_ODT150_533 (Input), DM_INPUT_667 (Input), DM_ODT50_667 (Input), DM_ODT75_667 (Input), DM_ODT150_667 (Input), DM_INPUT_1066 (Input), DM_ODT50_1066 (Input), DM_ODT75_1066 (Input), DM_ODT150_1066 (Input), INPUT_533 (Input), INPUT_667 (Input), INPUT_1066 (Input), CLKIN_533 (Input), CLKIN_667 (Input), CLKIN_1066 (Input), NF_INPUT (Terminator), 50ohm_ODT_533 (Dynamic_clamp), 75ohm_ODT_533 (Dynamic_clamp), 150ohm_ODT_533 (Dynamic_clamp), 50ohm_ODT_667 (Dynamic_clamp), 75ohm_ODT_667 (Dynamic_clamp), 150ohm_ODT_667 (Dynamic_clamp), 50ohm_ODT_1066 (Dynamic_clamp), 75ohm_ODT_1066 (Dynamic_clamp), 150ohm_ODT_1066 (Dynamic_clamp)
